# Ansys Electronics Desktop project, version 2021.2
materials:
  vacuum: permittivity=1
  pec: conductivity=1e+30
  silicon: permittivity=11.9
  copper: permeability=0.999991 conductivity=58000000
  perfect conductor: conductivity=1e+30
  FR4_epoxy: permittivity=4.4 dielectric_loss_tangent=0.02

design xmon2 (HFSS, DrivenModal, model units mm)
geometry:
  trace_cpw1_path = polyline((-0.001, 0, 0) (-0.0002, 0, 0))
  trace_cpw1 = polyline((-0.001, 5e-06, 0) (-0.001, -5e-06, 0))
  trace_cpw1.sweep_along_path(trace_cpw1_path)
  trace_cpw2_path = polyline((0, 0.001, 0) (0, 0.0002, 0))
  trace_cpw2 = polyline((5e-06, 0.001, 0) (-5e-06, 0.001, 0))
  trace_cpw2.sweep_along_path(trace_cpw2_path)
  trace_cpw3_path = polyline((0.001, 0, 0) (0.0002, 0, 0))
  trace_cpw3 = polyline((0.001, -5e-06, 0) (0.001, 5e-06, 0))
  trace_cpw3.sweep_along_path(trace_cpw3_path)
  trace_flux_cpw_small_path = polyline(z=0, xy: (-1.5e-05, -0.00014) (1e-05, -0.00014) (1e-05, -0.00025))
  trace_flux_cpw_small = polyline((-1.5e-05, -0.0001375, 0) (-1.5e-05, -0.0001425, 0))
  trace_flux_cpw_small.sweep_along_path(trace_flux_cpw_small_path)
  trace_flux_cpw_path = polyline(z=0, xy: (1e-05, -0.0003) (1e-05, -0.0004) (0.0005, -0.0004) (0.0005, -0.001))
  trace_flux_cpw_path.fillet(Vertices=trace_flux_cpw_path.vertex(2 of 4, 3 of 4) Radius=9e-05 Setback=0mm)
  trace_flux_cpw = polyline((1.5e-05, -0.0003, 0) (5e-06, -0.0003, 0))
  trace_flux_cpw.sweep_along_path(trace_flux_cpw_path)
  g_wb [pec] = bondwire(WireType=LOW WireDiameter=0.015mm NumSides=6 XPadPos=-0.00073333333 YPadPos=-5.5e-05 ZPadPos=0 XDir=0 YDir=1 ZDir=0 Distance=0.00011 h1=0.00011 h2=0mm alpha=80deg beta=80deg WhichAxis=Z)
  g_wb_1 [pec] = bondwire(WireType=LOW WireDiameter=0.015mm NumSides=6 XPadPos=-0.00046666667 YPadPos=-5.5e-05 ZPadPos=0 XDir=0 YDir=1 ZDir=0 Distance=0.00011 h1=0.00011 h2=0mm alpha=80deg beta=80deg WhichAxis=Z)
  g_wb_2 [pec] = bondwire(WireType=LOW WireDiameter=0.015mm NumSides=6 XPadPos=-5.5e-05 YPadPos=0.00073333333 ZPadPos=0 XDir=1 YDir=0 ZDir=0 Distance=0.00011 h1=0.00011 h2=0mm alpha=80deg beta=80deg WhichAxis=Z)
  g_wb_3 [pec] = bondwire(WireType=LOW WireDiameter=0.015mm NumSides=6 XPadPos=-5.5e-05 YPadPos=0.00046666667 ZPadPos=0 XDir=1 YDir=0 ZDir=0 Distance=0.00011 h1=0.00011 h2=0mm alpha=80deg beta=80deg WhichAxis=Z)
  g_wb_4 [pec] = bondwire(WireType=LOW WireDiameter=0.015mm NumSides=6 XPadPos=0.00073333333 YPadPos=5.5e-05 ZPadPos=0 XDir=0 YDir=-1 ZDir=0 Distance=0.00011 h1=0.00011 h2=0mm alpha=80deg beta=80deg WhichAxis=Z)
  g_wb_5 [pec] = bondwire(WireType=LOW WireDiameter=0.015mm NumSides=6 XPadPos=0.00046666667 YPadPos=5.5e-05 ZPadPos=0 XDir=0 YDir=-1 ZDir=0 Distance=0.00011 h1=0.00011 h2=0mm alpha=80deg beta=80deg WhichAxis=Z)
  g_wb_6 [pec] = bondwire(WireType=LOW WireDiameter=0.015mm NumSides=6 XPadPos=0.000255 YPadPos=-0.000455 ZPadPos=0 XDir=0 YDir=1 ZDir=0 Distance=0.00011 h1=0.00011 h2=0mm alpha=80deg beta=80deg WhichAxis=Z)
  g_wb_7 [pec] = bondwire(WireType=LOW WireDiameter=0.015mm NumSides=6 XPadPos=0.000445 YPadPos=-0.0007 ZPadPos=0 XDir=1 YDir=0 ZDir=0 Distance=0.00011 h1=0.00011 h2=0mm alpha=80deg beta=80deg WhichAxis=Z)
  g_wb_8 [pec] = bondwire(WireType=LOW WireDiameter=0.015mm NumSides=6 XPadPos=-0.000555 YPadPos=-0.00065 ZPadPos=0 XDir=1 YDir=0 ZDir=0 Distance=0.00011 h1=0.00011 h2=0mm alpha=80deg beta=80deg WhichAxis=Z)
  main [silicon] = box(corner=(-0.001, -0.001, -0.00075), size=(0.002, 0.002, 0.00075))
  sample_holder [vacuum] = box(corner=(-0.001, -0.001, -0.00165), size=(0.002, 0.002, 0.00254))
  WP1 = rectangle(corner=(-0.001, -0.0005, -0.00025), y_size=0.001, z_size=0.0005)
  WP2 = rectangle(corner=(-0.0005, 0.001, -0.00025), z_size=0.0005, x_size=0.001)
  WP3 = rectangle(corner=(0.001, -0.0005, -0.00025), y_size=0.001, z_size=0.0005)
  WP_ctrl = rectangle(corner=(-0.0009, -0.001, -0.00025), z_size=0.0005, x_size=0.0008)
  WP_flux = rectangle(corner=(0.0001, -0.001, -0.00025), z_size=0.0005, x_size=0.0008)
  cpw_add = polyline(z=0mm, xy in mm: (-0.2, 0.0075) (-0.22, 0.005) (-0.2, 0.005) (-0.2, 0.0075), closed, covered)
  cpw3 = cpw_add.duplicate_mirror(point=(-0.2mm, 0mm, 0mm), normal=(0mm, 1mm, 0mm))
  cpw_add_2, cpw_add_3 = cpw_add.duplicate_around_axis(axis=Z, angle=-90deg, total=3)
  cpw_add_1_1, cpw_add_1_2 = cpw3.duplicate_around_axis(axis=Z, angle=-90deg, total=3)
  cpw3.unite(cpw_add_1_1, cpw_add_1_2, cpw_add_2, cpw_add_3, cpw_add, trace_cpw1, trace_cpw2, trace_cpw3)
  Rectangle2 = rectangle(corner=(0.005mm, -0.3mm, 0mm), x_size=0.01mm, y_size=0.04mm)
  flux_trace = polyline(z=0mm, xy in mm: (0.0075, -0.25) (0.005, -0.26) (0.015, -0.26) (0.0125, -0.25) (0.0075, -0.25), closed, covered)
  flux_trace.unite(Rectangle2, trace_flux_cpw, trace_flux_cpw_small)
  JJ = rectangle(corner=(-0.0025mm, -0.125mm, 0mm), x_size=0.005mm, y_size=-0.005mm)
  cpw1, cpw2 = cpw3.separate_bodies()
  c1_connector = polyline(z=0mm, xy in mm: (-0.2, 0.0075) (-0.2, -0.0075) (-0.155, -0.0075) (-0.155, -0.0425) (-0.06, -0.0425) (-0.06, -0.0275) (-0.14, -0.0275) (-0.14, 0.0275) (-0.06, 0.0275) (-0.06, 0.0425) (-0.155, 0.0425) (-0.155, 0.0075) (-0.2, 0.0075), closed, covered)
  c2_connector, c3_connector = c1_connector.duplicate_around_axis(axis=Z, angle=-90deg, total=3)
  cross = polyline(z=0mm, xy in mm: (-0.0125, 0.125) (-0.0125, 0.0125) (-0.125, 0.0125) (-0.125, -0.0125) (-0.0125, -0.0125) (-0.0125, -0.125) (0.0125, -0.125) (0.0125, -0.0125) (0.125, -0.0125) (0.125, 0.0125) (0.0125, 0.0125) (0.0125, 0.125) (-0.0125, 0.125), closed, covered)
  Polyline5 = polyline(z=0mm, xy in mm: (0.0125, -0.241) (0.015, -0.26) (0.0125, -0.25) (0.0125, -0.241), closed, covered)
  Polyline6 = polyline(z=0mm, xy in mm: (0.0075, -0.241) (0.005, -0.26) (0.0075, -0.25) (0.0075, -0.241), closed, covered)
  flux_trace.unite(Polyline5, Polyline6)
  Polyline15 = polyline(z=0mm, xy in mm: (0.0075, -0.241) (0.0075, -0.26) (0.005, -0.26) (0.0075, -0.241), closed, covered)
  Polyline16 = polyline(z=0mm, xy in mm: (0.0125, -0.241) (0.0125, -0.26) (0.015, -0.26) (0.0125, -0.241), closed, covered)
  flux_trace.subtract(Polyline15, Polyline16)
  Polyline18 = polyline(z=0mm, xy in mm: (0.005, -0.26) (0.0075, -0.24) (0.0075, -0.26) (0.005, -0.26), closed, covered)
  Polyline19 = polyline(z=0mm, xy in mm: (0.0125, -0.24) (0.0125, -0.26) (0.015, -0.26) (0.0125, -0.24), closed, covered)
  flux_trace.unite(Polyline18, Polyline19)
  trace_ctrl_cpw, ground_main_plane [vacuum] = imported_body()
  Rectangle3 = rectangle(corner=(-0.045mm, -0.1025mm, 0mm), x_size=-0.01mm, y_size=-0.005mm)
  trace_ctrl_cpw.subtract(Rectangle3)
boundaries and excitations:
  PerfE1: Perfect E Objects=[c1_connector, c2_connector, c3_connector, cpw1, cpw2, cpw3, cross, flux_trace, ground_main_plane, trace_ctrl_cpw]
  WP1: Wave Port Objects=WP1 NumModes=1 Modes{Mode1{IntLine{middle of cpw3.edge(1 of 1) -> ?.vertex(#1683)} CharImp=Zpi RenormImp=50ohm}}
  WP2: Wave Port Objects=WP2 NumModes=1 Modes{Mode1{IntLine{middle of cpw3.edge(1 of 1) -> ?.vertex(#1667)} CharImp=Zpi RenormImp=50ohm}}
  WP3: Wave Port Objects=WP3 NumModes=1 Modes{Mode1{IntLine{middle of cpw3.edge(1 of 1) -> ?.vertex(#1651)} CharImp=Zpi RenormImp=50ohm}}
  WP_ctrl: Wave Port Objects=WP_ctrl NumModes=1 Modes{Mode1{IntLine{main.edge(4 of 12) at 0.25 along -> ?.vertex(#1699)} CharImp=Zpi RenormImp=50ohm}}
  WP_flux: Wave Port Objects=WP_flux NumModes=1 Modes{Mode1{IntLine{middle of flux_trace.edge(#181) -> ?.vertex(#1639)} CharImp=Zpi RenormImp=50ohm}}
  JJ: Lumped Port Objects=JJ Modes{Mode1{IntLine{middle of JJ.edge(y at corner) -> middle of JJ.edge(y opposite corner)} CharImp=Zpi RenormImp=50ohm}} Impedance=50ohm
mesh:
  cpw: LengthBased Objects=[cpw1, cpw2, cpw3, flux_trace, trace_ctrl_cpw] MaxLength=0.005mm
  jj_port: LengthBased Objects=JJ MaxLength=0.001mm
  connectors: LengthBased Objects=[c1_connector, c2_connector, c3_connector] MaxLength=0.01mm
  cross: LengthBased Objects=cross MaxLength=0.02mm
setups:
  SingleFreq_20_5GHz: HfssDriven Frequency=20.5GHz MaxDeltaS=0.01 MaximumPasses=15 MinimumPasses=1 MinimumConvergedPasses=1 PercentRefinement=30 BasisOrder=1 PortAccuracy=2
    sweep Int: 500MHz to 20.5GHz, 25000 points; Type=Interpolating InterpTolerance=0.25 InterpMaxSolns=250 InterpUsePortImped=false PassivityErrorTolerance=5e-05
source amplitudes:
  WP1:1, WP2:1, WP3:1, WP_ctrl:1, WP_flux:1: 0W 0deg
  JJ:1: 100W 0deg
field plots:
  Mag_E1: E Field on SingleFreq_20_5GHz : LastAdaptive at Freq=20.5GHz Phase=0deg
  Mesh1: MeshPlots on SingleFreq_20_5GHz : LastAdaptive at Freq=20.5GHz Phase=0deg
reports:
  Z Parameter Plot 2: dB20(Z(JJ,JJ)) vs Freq on SingleFreq_20_5GHz : Int; markers MX1 at x=9.9231913e+08
  S Parameter Plot 1: dB(S(WP_ctrl,JJ)), dB(S(WP_flux,JJ)), dB(S(WP1,JJ)), dB(S(WP2,JJ)), dB(S(WP3,JJ)) vs Freq on SingleFreq_20_5GHz : Int

design xmon2_ports (HFSS, DrivenModal, model units mm)
geometry:
  trace_cpw1_path = polyline((-0.001, 0, 0) (-0.0002, 0, 0))
  trace_cpw1 = polyline((-0.001, 5e-06, 0) (-0.001, -5e-06, 0))
  trace_cpw1.sweep_along_path(trace_cpw1_path)
  trace_cpw2_path = polyline((0, 0.001, 0) (0, 0.0002, 0))
  trace_cpw2 = polyline((5e-06, 0.001, 0) (-5e-06, 0.001, 0))
  trace_cpw2.sweep_along_path(trace_cpw2_path)
  trace_cpw3_path = polyline((0.001, 0, 0) (0.0002, 0, 0))
  trace_cpw3 = polyline((0.001, -5e-06, 0) (0.001, 5e-06, 0))
  trace_cpw3.sweep_along_path(trace_cpw3_path)
  trace_flux_cpw_small_path = polyline(z=0, xy: (-1.5e-05, -0.00014) (1e-05, -0.00014) (1e-05, -0.00025))
  trace_flux_cpw_small = polyline((-1.5e-05, -0.0001375, 0) (-1.5e-05, -0.0001425, 0))
  trace_flux_cpw_small.sweep_along_path(trace_flux_cpw_small_path)
  trace_flux_cpw_path = polyline(z=0, xy: (1e-05, -0.0003) (1e-05, -0.0004) (0.0005, -0.0004) (0.0005, -0.001))
  trace_flux_cpw_path.fillet(Vertices=trace_flux_cpw_path.vertex(2 of 4, 3 of 4) Radius=9e-05 Setback=0mm)
  trace_flux_cpw = polyline((1.5e-05, -0.0003, 0) (5e-06, -0.0003, 0))
  trace_flux_cpw.sweep_along_path(trace_flux_cpw_path)
  g_wb [pec] = bondwire(WireType=LOW WireDiameter=0.015mm NumSides=6 XPadPos=-0.00073333333 YPadPos=-5.5e-05 ZPadPos=0 XDir=0 YDir=1 ZDir=0 Distance=0.00011 h1=0.00011 h2=0mm alpha=80deg beta=80deg WhichAxis=Z)
  g_wb_1 [pec] = bondwire(WireType=LOW WireDiameter=0.015mm NumSides=6 XPadPos=-0.00046666667 YPadPos=-5.5e-05 ZPadPos=0 XDir=0 YDir=1 ZDir=0 Distance=0.00011 h1=0.00011 h2=0mm alpha=80deg beta=80deg WhichAxis=Z)
  g_wb_2 [pec] = bondwire(WireType=LOW WireDiameter=0.015mm NumSides=6 XPadPos=-5.5e-05 YPadPos=0.00073333333 ZPadPos=0 XDir=1 YDir=0 ZDir=0 Distance=0.00011 h1=0.00011 h2=0mm alpha=80deg beta=80deg WhichAxis=Z)
  g_wb_3 [pec] = bondwire(WireType=LOW WireDiameter=0.015mm NumSides=6 XPadPos=-5.5e-05 YPadPos=0.00046666667 ZPadPos=0 XDir=1 YDir=0 ZDir=0 Distance=0.00011 h1=0.00011 h2=0mm alpha=80deg beta=80deg WhichAxis=Z)
  g_wb_4 [pec] = bondwire(WireType=LOW WireDiameter=0.015mm NumSides=6 XPadPos=0.00073333333 YPadPos=5.5e-05 ZPadPos=0 XDir=0 YDir=-1 ZDir=0 Distance=0.00011 h1=0.00011 h2=0mm alpha=80deg beta=80deg WhichAxis=Z)
  g_wb_5 [pec] = bondwire(WireType=LOW WireDiameter=0.015mm NumSides=6 XPadPos=0.00046666667 YPadPos=5.5e-05 ZPadPos=0 XDir=0 YDir=-1 ZDir=0 Distance=0.00011 h1=0.00011 h2=0mm alpha=80deg beta=80deg WhichAxis=Z)
  g_wb_6 [pec] = bondwire(WireType=LOW WireDiameter=0.015mm NumSides=6 XPadPos=0.000255 YPadPos=-0.000455 ZPadPos=0 XDir=0 YDir=1 ZDir=0 Distance=0.00011 h1=0.00011 h2=0mm alpha=80deg beta=80deg WhichAxis=Z)
  g_wb_7 [pec] = bondwire(WireType=LOW WireDiameter=0.015mm NumSides=6 XPadPos=0.000445 YPadPos=-0.0007 ZPadPos=0 XDir=1 YDir=0 ZDir=0 Distance=0.00011 h1=0.00011 h2=0mm alpha=80deg beta=80deg WhichAxis=Z)
  g_wb_8 [pec] = bondwire(WireType=LOW WireDiameter=0.015mm NumSides=6 XPadPos=-0.000555 YPadPos=-0.00065 ZPadPos=0 XDir=1 YDir=0 ZDir=0 Distance=0.00011 h1=0.00011 h2=0mm alpha=80deg beta=80deg WhichAxis=Z)
  main [silicon] = box(corner=(-0.001, -0.001, -0.00075), size=(0.002, 0.002, 0.00075))
  sample_holder [vacuum] = box(corner=(-0.001, -0.001, -0.00165), size=(0.002, 0.002, 0.00254))
  WP1 = rectangle(corner=(-0.001, -0.0005, -0.00025), y_size=0.001, z_size=0.0005)
  WP2 = rectangle(corner=(-0.0005, 0.001, -0.00025), z_size=0.0005, x_size=0.001)
  WP3 = rectangle(corner=(0.001, -0.0005, -0.00025), y_size=0.001, z_size=0.0005)
  WP_ctrl = rectangle(corner=(-0.0009, -0.001, -0.00025), z_size=0.0005, x_size=0.0008)
  WP_flux = rectangle(corner=(0.0001, -0.001, -0.00025), z_size=0.0005, x_size=0.0008)
  cpw_add = polyline(z=0mm, xy in mm: (-0.2, 0.0075) (-0.22, 0.005) (-0.2, 0.005) (-0.2, 0.0075), closed, covered)
  cpw3 = cpw_add.duplicate_mirror(point=(-0.2mm, 0mm, 0mm), normal=(0mm, 1mm, 0mm))
  cpw_add_2, cpw_add_3 = cpw_add.duplicate_around_axis(axis=Z, angle=-90deg, total=3)
  cpw_add_1_1, cpw_add_1_2 = cpw3.duplicate_around_axis(axis=Z, angle=-90deg, total=3)
  cpw3.unite(cpw_add_1_1, cpw_add_1_2, cpw_add_2, cpw_add_3, cpw_add, trace_cpw1, trace_cpw2, trace_cpw3)
  Rectangle2 = rectangle(corner=(0.005mm, -0.3mm, 0mm), x_size=0.01mm, y_size=0.04mm)
  flux_trace = polyline(z=0mm, xy in mm: (0.0075, -0.25) (0.005, -0.26) (0.015, -0.26) (0.0125, -0.25) (0.0075, -0.25), closed, covered)
  flux_trace.unite(Rectangle2, trace_flux_cpw, trace_flux_cpw_small)
  JJ = rectangle(corner=(-0.0025mm, -0.125mm, 0mm), x_size=0.005mm, y_size=-0.005mm)
  cpw1, cpw2 = cpw3.separate_bodies()
  c1_connector = polyline(z=0mm, xy in mm: (-0.2, 0.0075) (-0.2, -0.0075) (-0.155, -0.0075) (-0.155, -0.0425) (-0.06, -0.0425) (-0.06, -0.0275) (-0.14, -0.0275) (-0.14, 0.0275) (-0.06, 0.0275) (-0.06, 0.0425) (-0.155, 0.0425) (-0.155, 0.0075) (-0.2, 0.0075), closed, covered)
  c2_connector, c3_connector = c1_connector.duplicate_around_axis(axis=Z, angle=-90deg, total=3)
  cross = polyline(z=0mm, xy in mm: (-0.0125, 0.125) (-0.0125, 0.0125) (-0.125, 0.0125) (-0.125, -0.0125) (-0.0125, -0.0125) (-0.0125, -0.125) (0.0125, -0.125) (0.0125, -0.0125) (0.125, -0.0125) (0.125, 0.0125) (0.0125, 0.0125) (0.0125, 0.125) (-0.0125, 0.125), closed, covered)
  Polyline5 = polyline(z=0mm, xy in mm: (0.0125, -0.241) (0.015, -0.26) (0.0125, -0.25) (0.0125, -0.241), closed, covered)
  Polyline6 = polyline(z=0mm, xy in mm: (0.0075, -0.241) (0.005, -0.26) (0.0075, -0.25) (0.0075, -0.241), closed, covered)
  flux_trace.unite(Polyline5, Polyline6)
  Polyline15 = polyline(z=0mm, xy in mm: (0.0075, -0.241) (0.0075, -0.26) (0.005, -0.26) (0.0075, -0.241), closed, covered)
  Polyline16 = polyline(z=0mm, xy in mm: (0.0125, -0.241) (0.0125, -0.26) (0.015, -0.26) (0.0125, -0.241), closed, covered)
  flux_trace.subtract(Polyline15, Polyline16)
  Polyline18 = polyline(z=0mm, xy in mm: (0.005, -0.26) (0.0075, -0.24) (0.0075, -0.26) (0.005, -0.26), closed, covered)
  Polyline19 = polyline(z=0mm, xy in mm: (0.0125, -0.24) (0.0125, -0.26) (0.015, -0.26) (0.0125, -0.24), closed, covered)
  flux_trace.unite(Polyline18, Polyline19)
  trace_ctrl_cpw, ground_main_plane [vacuum] = imported_body()
  Rectangle3 = rectangle(corner=(-0.045mm, -0.1025mm, 0mm), x_size=-0.01mm, y_size=-0.005mm)
  trace_ctrl_cpw.subtract(Rectangle3)
boundaries and excitations:
  PerfE1: Perfect E Objects=[c1_connector, c2_connector, c3_connector, cpw1, cpw2, cpw3, cross, flux_trace, ground_main_plane, trace_ctrl_cpw]
  WP1: Wave Port Objects=WP1 NumModes=1 Modes{Mode1{IntLine{middle of cpw3.edge(1 of 1) -> ?.vertex(#1683)} CharImp=Zpi}}
  WP2: Wave Port Objects=WP2 NumModes=1 Modes{Mode1{IntLine{middle of cpw3.edge(1 of 1) -> ?.vertex(#1667)} CharImp=Zpi}}
  WP3: Wave Port Objects=WP3 NumModes=1 Modes{Mode1{IntLine{middle of cpw3.edge(1 of 1) -> ?.vertex(#1651)} CharImp=Zpi}}
  WP_ctrl: Wave Port Objects=WP_ctrl NumModes=1 Modes{Mode1{IntLine{main.edge(4 of 12) at 0.25 along -> ?.vertex(#1699)} CharImp=Zpi}}
  WP_flux: Wave Port Objects=WP_flux NumModes=1 Modes{Mode1{IntLine{middle of flux_trace.edge(#181) -> ?.vertex(#1639)} CharImp=Zpi}}
  JJ: Lumped Port Objects=JJ Modes{Mode1{IntLine{middle of JJ.edge(y at corner) -> middle of JJ.edge(y opposite corner)} CharImp=Zpi}} Impedance=50ohm
mesh:
  cpw: LengthBased Objects=[cpw1, cpw2, cpw3, flux_trace, trace_ctrl_cpw] MaxLength=0.005mm
  jj_port: LengthBased Objects=JJ MaxLength=0.001mm
  connectors: LengthBased Objects=[c1_connector, c2_connector, c3_connector] MaxLength=0.01mm
  cross: LengthBased Objects=cross MaxLength=0.02mm
setups:
  SingleFreq_20_5GHz: HfssDriven Frequency=5GHz MaxDeltaS=0.01 MaximumPasses=15 MinimumPasses=1 MinimumConvergedPasses=1 PercentRefinement=30 BasisOrder=1 PortAccuracy=1
source amplitudes:
  WP1:1, WP2:1, WP3:1, WP_ctrl:1, WP_flux:1: 0W 0deg
  JJ:1: 100W 0deg
field plots:
  Mesh1: MeshPlots on SingleFreq_20_5GHz : PortOnly at Freq=5GHz Phase=0deg

design xmon_cap (Q3D Extractor, model units mm)
options: SParamCalcMethod=EqTransLine Calculate_Lossy_Dielectrics
geometry:
  trace_ctrl_cpw [vacuum] = imported_body()
  g_wb [pec] = bondwire(WireType=LOW WireDiameter=0.015mm NumSides=6 XPadPos=-0.00073333333 YPadPos=-5.5e-05 ZPadPos=0 XDir=0 YDir=1 ZDir=0 Distance=0.00011 h1=0.00011 h2=0mm alpha=80deg beta=80deg WhichAxis=Z)
  g_wb_1 [pec] = bondwire(WireType=LOW WireDiameter=0.015mm NumSides=6 XPadPos=-0.00046666667 YPadPos=-5.5e-05 ZPadPos=0 XDir=0 YDir=1 ZDir=0 Distance=0.00011 h1=0.00011 h2=0mm alpha=80deg beta=80deg WhichAxis=Z)
  g_wb_2 [pec] = bondwire(WireType=LOW WireDiameter=0.015mm NumSides=6 XPadPos=-5.5e-05 YPadPos=0.00073333333 ZPadPos=0 XDir=1 YDir=0 ZDir=0 Distance=0.00011 h1=0.00011 h2=0mm alpha=80deg beta=80deg WhichAxis=Z)
  g_wb_3 [pec] = bondwire(WireType=LOW WireDiameter=0.015mm NumSides=6 XPadPos=-5.5e-05 YPadPos=0.00046666667 ZPadPos=0 XDir=1 YDir=0 ZDir=0 Distance=0.00011 h1=0.00011 h2=0mm alpha=80deg beta=80deg WhichAxis=Z)
  g_wb_4 [pec] = bondwire(WireType=LOW WireDiameter=0.015mm NumSides=6 XPadPos=0.00073333333 YPadPos=5.5e-05 ZPadPos=0 XDir=0 YDir=-1 ZDir=0 Distance=0.00011 h1=0.00011 h2=0mm alpha=80deg beta=80deg WhichAxis=Z)
  g_wb_5 [pec] = bondwire(WireType=LOW WireDiameter=0.015mm NumSides=6 XPadPos=0.00046666667 YPadPos=5.5e-05 ZPadPos=0 XDir=0 YDir=-1 ZDir=0 Distance=0.00011 h1=0.00011 h2=0mm alpha=80deg beta=80deg WhichAxis=Z)
  g_wb_6 [pec] = bondwire(WireType=LOW WireDiameter=0.015mm NumSides=6 XPadPos=0.000255 YPadPos=-0.000455 ZPadPos=0 XDir=0 YDir=1 ZDir=0 Distance=0.00011 h1=0.00011 h2=0mm alpha=80deg beta=80deg WhichAxis=Z)
  g_wb_7 [pec] = bondwire(WireType=LOW WireDiameter=0.015mm NumSides=6 XPadPos=0.000445 YPadPos=-0.0007 ZPadPos=0 XDir=1 YDir=0 ZDir=0 Distance=0.00011 h1=0.00011 h2=0mm alpha=80deg beta=80deg WhichAxis=Z)
  g_wb_8 [pec] = bondwire(WireType=LOW WireDiameter=0.015mm NumSides=6 XPadPos=-0.000555 YPadPos=-0.00065 ZPadPos=0 XDir=1 YDir=0 ZDir=0 Distance=0.00011 h1=0.00011 h2=0mm alpha=80deg beta=80deg WhichAxis=Z)
  ground_main_plane [vacuum] = imported_body()
  main [silicon] = box(corner=(-0.001, -0.001, -0.00075), size=(0.002, 0.002, 0.00075))
  sample_holder [vacuum] = box(corner=(-0.001, -0.001, -0.00165), size=(0.002, 0.002, 0.00254))
  cpw_add = polyline(z=0mm, xy in mm: (-0.2, 0.0075) (-0.22, 0.005) (-0.2, 0.005) (-0.2, 0.0075), closed, covered)
  cpw3 = cpw_add.duplicate_mirror(point=(-0.2mm, 0mm, 0mm), normal=(0mm, 1mm, 0mm))
  cpw_add_1_1, cpw_add_1_2 = cpw3.duplicate_around_axis(axis=Z, angle=-90deg, total=3)
  cpw_add_2, cpw_add_3 = cpw_add.duplicate_around_axis(axis=Z, angle=-90deg, total=3)
  trace_cpw1 = polyline((-0.001, 5e-06, 0) (-0.001, -5e-06, 0))
  trace_cpw1_path = polyline((-0.001, 0, 0) (-0.0002, 0, 0))
  trace_cpw1.sweep_along_path(trace_cpw1_path)
  trace_cpw2 = polyline((5e-06, 0.001, 0) (-5e-06, 0.001, 0))
  trace_cpw2_path = polyline((0, 0.001, 0) (0, 0.0002, 0))
  trace_cpw2.sweep_along_path(trace_cpw2_path)
  trace_cpw3 = polyline((0.001, -5e-06, 0) (0.001, 5e-06, 0))
  trace_cpw3_path = polyline((0.001, 0, 0) (0.0002, 0, 0))
  trace_cpw3.sweep_along_path(trace_cpw3_path)
  cpw3.unite(cpw_add_1_1, cpw_add_1_2, cpw_add_2, cpw_add_3, cpw_add, trace_cpw1, trace_cpw2, trace_cpw3)
  cpw1, cpw2 = cpw3.separate_bodies()
  flux_trace = polyline(z=0mm, xy in mm: (0.0075, -0.25) (0.005, -0.26) (0.015, -0.26) (0.0125, -0.25) (0.0075, -0.25), closed, covered)
  Rectangle2 = rectangle(corner=(0.005mm, -0.3mm, 0mm), x_size=0.01mm, y_size=0.04mm)
  trace_flux_cpw = polyline((1.5e-05, -0.0003, 0) (5e-06, -0.0003, 0))
  trace_flux_cpw_path = polyline(z=0, xy: (1e-05, -0.0003) (1e-05, -0.0004) (0.0005, -0.0004) (0.0005, -0.001))
  trace_flux_cpw_path.fillet(Vertices=trace_flux_cpw_path.vertex(2 of 4, 3 of 4) Radius=9e-05 Setback=0mm)
  trace_flux_cpw.sweep_along_path(trace_flux_cpw_path)
  trace_flux_cpw_small = polyline((-1.5e-05, -0.0001375, 0) (-1.5e-05, -0.0001425, 0))
  trace_flux_cpw_small_path = polyline(z=0, xy: (-1.5e-05, -0.00014) (1e-05, -0.00014) (1e-05, -0.00025))
  trace_flux_cpw_small.sweep_along_path(trace_flux_cpw_small_path)
  flux_trace.unite(Rectangle2, trace_flux_cpw, trace_flux_cpw_small)
  Polyline5 = polyline(z=0mm, xy in mm: (0.0125, -0.241) (0.015, -0.26) (0.0125, -0.25) (0.0125, -0.241), closed, covered)
  Polyline6 = polyline(z=0mm, xy in mm: (0.0075, -0.241) (0.005, -0.26) (0.0075, -0.25) (0.0075, -0.241), closed, covered)
  flux_trace.unite(Polyline5, Polyline6)
  Polyline15 = polyline(z=0mm, xy in mm: (0.0075, -0.241) (0.0075, -0.26) (0.005, -0.26) (0.0075, -0.241), closed, covered)
  Polyline16 = polyline(z=0mm, xy in mm: (0.0125, -0.241) (0.0125, -0.26) (0.015, -0.26) (0.0125, -0.241), closed, covered)
  flux_trace.subtract(Polyline15, Polyline16)
  Polyline18 = polyline(z=0mm, xy in mm: (0.005, -0.26) (0.0075, -0.24) (0.0075, -0.26) (0.005, -0.26), closed, covered)
  Polyline19 = polyline(z=0mm, xy in mm: (0.0125, -0.24) (0.0125, -0.26) (0.015, -0.26) (0.0125, -0.24), closed, covered)
  flux_trace.unite(Polyline18, Polyline19)
  c1_connector = polyline(z=0mm, xy in mm: (-0.2, 0.0075) (-0.2, -0.0075) (-0.155, -0.0075) (-0.155, -0.0425) (-0.06, -0.0425) (-0.06, -0.0275) (-0.14, -0.0275) (-0.14, 0.0275) (-0.06, 0.0275) (-0.06, 0.0425) (-0.155, 0.0425) (-0.155, 0.0075) (-0.2, 0.0075), closed, covered)
  c2_connector, c3_connector = c1_connector.duplicate_around_axis(axis=Z, angle=-90deg, total=3)
  cross = polyline(z=0mm, xy in mm: (-0.0125, 0.125) (-0.0125, 0.0125) (-0.125, 0.0125) (-0.125, -0.0125) (-0.0125, -0.0125) (-0.0125, -0.125) (0.0125, -0.125) (0.0125, -0.0125) (0.125, -0.0125) (0.125, 0.0125) (0.0125, 0.0125) (0.0125, 0.125) (-0.0125, 0.125), closed, covered)
  ground_main_plane.unite(flux_trace)
  cpw1.unite(c1_connector)
  cpw2.unite(c2_connector)
  cpw3.unite(c3_connector)
  Rectangle3 = rectangle(corner=(-0.045mm, -0.1025mm, 0mm), x_size=-0.01mm, y_size=-0.005mm)
  trace_ctrl_cpw.subtract(Rectangle3)
boundaries and excitations:
  ThinCond1: ThinConductor Objects=[cpw1, cpw2, cpw3, cross, ground_main_plane, trace_ctrl_cpw] Material="perfect conductor" Thickness=250nm
  GroundNet1: GroundNet Objects=[g_wb, g_wb_1..g_wb_8, ground_main_plane]
  cpw1: SignalNet Objects=cpw1
  cpw2: SignalNet Objects=cpw2
  cpw3: SignalNet Objects=cpw3
  cross: SignalNet Objects=cross
  ctrl: SignalNet Objects=trace_ctrl_cpw
mesh:
  cpw: LengthBased Objects=[cpw1, cpw2, cpw3, trace_ctrl_cpw] MaxLength=0.005mm
  cross: LengthBased Objects=cross MaxLength=0.005mm
  ground: LengthBased Objects=ground_main_plane MaxLength=0.02mm
  initial mesh: EnablePrime
setups:
  Cap1: Matrix AdaptiveFreq=4GHz Cap{MaxPass=10 MinPass=1 MinConvPass=1 PerError=1 PerRefine=30 AutoIncreaseSolutionOrder SolutionOrder=High Solver_Type=Iterative}
  Cap2: Matrix AdaptiveFreq=20.5GHz Cap{MaxPass=10 MinPass=1 MinConvPass=1 PerError=1 PerRefine=30 AutoIncreaseSolutionOrder SolutionOrder=High Solver_Type=Iterative}
  Cap3: Matrix AdaptiveFreq=250MHz Cap{MaxPass=10 MinPass=1 MinConvPass=1 PerError=1 PerRefine=30 AutoIncreaseSolutionOrder SolutionOrder=Normal Solver_Type=Iterative}
source amplitudes:
  cpw1: Cap 1V 0deg
  cpw2, cpw3, cross, ctrl: Cap 0V 0deg

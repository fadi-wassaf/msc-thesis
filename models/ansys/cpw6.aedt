# Ansys Electronics Desktop project, version 2021.2
materials:
  vacuum: permittivity=1
  pec: conductivity=1e+30
  silicon: permittivity=11.9

design cpw6 (HFSS, DrivenModal, model units mm)
geometry:
  trace_c1_path = polyline(z=0, xy: (-0.001, 0) (-0.0005, 0) (-0.0005, 0.00055365046) (-0.00025, 0.00055365046) (-0.00025, -0.00055365046) (0, -0.00055365046) (0, 0.00055365046) (0.00025, 0.00055365046) (0.00025, -0.00055365046) (0.0005, -0.00055365046) (0.0005, 0) (0.001, 0))
  trace_c1_path.fillet(Vertices=trace_c1_path.vertex(2 of 12, 3 of 12, 4 of 12, 5 of 12, 6 of 12, 7 of 12, 8 of 12, 9 of 12, 10 of 12, 11 of 12) Radius=0.0001 Setback=0mm)
  trace_c1 = polyline((-0.001, 5e-06, 0) (-0.001, -5e-06, 0))
  trace_c1.sweep_along_path(trace_c1_path)
  cut_c1_path = polyline(z=0, xy: (-0.001, 0) (-0.0005, 0) (-0.0005, 0.00055365046) (-0.00025, 0.00055365046) (-0.00025, -0.00055365046) (0, -0.00055365046) (0, 0.00055365046) (0.00025, 0.00055365046) (0.00025, -0.00055365046) (0.0005, -0.00055365046) (0.0005, 0) (0.001, 0))
  cut_c1_path.fillet(Vertices=cut_c1_path.vertex(2 of 12, 3 of 12, 4 of 12, 5 of 12, 6 of 12, 7 of 12, 8 of 12, 9 of 12, 10 of 12, 11 of 12) Radius=0.0001 Setback=0mm)
  cut_c1 = polyline((-0.001, 1.1e-05, 0) (-0.001, -1.1e-05, 0))
  cut_c1.sweep_along_path(cut_c1_path)
  g_wb [pec] = bondwire(WireType=LOW WireDiameter=0.015mm NumSides=6 XPadPos=-0.00075 YPadPos=-5.5e-05 ZPadPos=0 XDir=0 YDir=1 ZDir=0 Distance=0.00011 h1=0.00011 h2=0mm alpha=80deg beta=80deg WhichAxis=Z)
  g_wb_1 [pec] = bondwire(WireType=LOW WireDiameter=0.015mm NumSides=6 XPadPos=-0.000445 YPadPos=0.00027682523 ZPadPos=0 XDir=-1 YDir=0 ZDir=0 Distance=0.00011 h1=0.00011 h2=0mm alpha=80deg beta=80deg WhichAxis=Z)
  g_wb_2 [pec] = bondwire(WireType=LOW WireDiameter=0.015mm NumSides=6 XPadPos=-0.000305 YPadPos=0.00018455015 ZPadPos=0 XDir=1 YDir=0 ZDir=0 Distance=0.00011 h1=0.00011 h2=0mm alpha=80deg beta=80deg WhichAxis=Z)
  g_wb_3 [pec] = bondwire(WireType=LOW WireDiameter=0.015mm NumSides=6 XPadPos=-0.000305 YPadPos=-0.00018455015 ZPadPos=0 XDir=1 YDir=0 ZDir=0 Distance=0.00011 h1=0.00011 h2=0mm alpha=80deg beta=80deg WhichAxis=Z)
  g_wb_4 [pec] = bondwire(WireType=LOW WireDiameter=0.015mm NumSides=6 XPadPos=5.5e-05 YPadPos=-0.00018455015 ZPadPos=0 XDir=-1 YDir=0 ZDir=0 Distance=0.00011 h1=0.00011 h2=0mm alpha=80deg beta=80deg WhichAxis=Z)
  g_wb_5 [pec] = bondwire(WireType=LOW WireDiameter=0.015mm NumSides=6 XPadPos=5.5e-05 YPadPos=0.00018455015 ZPadPos=0 XDir=-1 YDir=0 ZDir=0 Distance=0.00011 h1=0.00011 h2=0mm alpha=80deg beta=80deg WhichAxis=Z)
  g_wb_6 [pec] = bondwire(WireType=LOW WireDiameter=0.015mm NumSides=6 XPadPos=0.000195 YPadPos=0.00018455015 ZPadPos=0 XDir=1 YDir=0 ZDir=0 Distance=0.00011 h1=0.00011 h2=0mm alpha=80deg beta=80deg WhichAxis=Z)
  g_wb_7 [pec] = bondwire(WireType=LOW WireDiameter=0.015mm NumSides=6 XPadPos=0.000195 YPadPos=-0.00018455015 ZPadPos=0 XDir=1 YDir=0 ZDir=0 Distance=0.00011 h1=0.00011 h2=0mm alpha=80deg beta=80deg WhichAxis=Z)
  g_wb_8 [pec] = bondwire(WireType=LOW WireDiameter=0.015mm NumSides=6 XPadPos=0.000555 YPadPos=-0.00027682523 ZPadPos=0 XDir=-1 YDir=0 ZDir=0 Distance=0.00011 h1=0.00011 h2=0mm alpha=80deg beta=80deg WhichAxis=Z)
  g_wb_9 [pec] = bondwire(WireType=LOW WireDiameter=0.015mm NumSides=6 XPadPos=0.00075 YPadPos=-5.5e-05 ZPadPos=0 XDir=0 YDir=1 ZDir=0 Distance=0.00011 h1=0.00011 h2=0mm alpha=80deg beta=80deg WhichAxis=Z)
  ground_main_plane = rectangle(corner=(-0.001, -0.001, 0), x_size=0.002, y_size=0.002)
  main [silicon] = box(corner=(-0.001, -0.001, -0.00075), size=(0.002, 0.002, 0.00075))
  sample_holder [vacuum] = box(corner=(-0.001, -0.001, -0.00165), size=(0.002, 0.002, 0.00254))
  ground_main_plane.subtract(cut_c1)
  WP1 = rectangle(corner=(-0.001, -0.0005, -0.00025), y_size=0.001, z_size=0.0005)
  WP2 = rectangle(corner=(0.001, -0.0005, -0.00025), y_size=0.001, z_size=0.0005)
boundaries and excitations:
  PerfE: Perfect E Objects=[trace_c1, ground_main_plane]
  WP1: Wave Port Objects=WP1 NumModes=1 Modes{Mode1{IntLine{middle of main.edge(3 of 12) -> ground_main_plane.vertex(#1322)} CharImp=Zpi RenormImp=50ohm}}
  WP2: Wave Port Objects=WP2 NumModes=1 Modes{Mode1{IntLine{middle of main.edge(1 of 12) -> ground_main_plane.vertex(#1298)} CharImp=Zpi RenormImp=50ohm}}
mesh:
  cpw: LengthBased Objects=trace_c1 MaxLength=0.005mm
setups:
  SingleFreq_20_5GHz: HfssDriven Frequency=20.5GHz MaxDeltaS=0.01 MaximumPasses=15 MinimumPasses=1 MinimumConvergedPasses=1 PercentRefinement=30 BasisOrder=1 PortAccuracy=2
    sweep Int: 500MHz to 20.5GHz, 25000 points; Type=Interpolating InterpTolerance=0.5 InterpMaxSolns=250 InterpUsePortImped=false PassivityErrorTolerance=0.0001
source amplitudes:
  WP1:1: 1W 0deg
  WP2:1: 0W 0deg
field plots:
  Mesh1: MeshPlots over ground_main_plane.face(all 2) trace_c1.face WP1.face WP2.face on SingleFreq_20_5GHz : LastAdaptive at Freq=20.5GHz Phase=0deg
reports:
  S Parameter Plot 1: dB(S(WP1,WP1)), dB(S(WP2,WP1)), dB(S(WP1,WP2)), dB(S(WP2,WP2)) vs Freq on SingleFreq_20_5GHz : Int
  Z Parameter Plot 1: dB20(Z(WP1,WP1)), dB20(Z(WP2,WP1)), dB20(Z(WP1,WP2)), dB20(Z(WP2,WP2)) vs Freq on SingleFreq_20_5GHz : Int; markers MX1 at x=9.8565273e+09
  Passivity Plot 1: Passivity vs Freq on SingleFreq_20_5GHz : Int
  Z Parameter Plot 2: im(Z(WP1,WP1)), im(Z(WP2,WP1)), im(Z(WP1,WP2)), im(Z(WP2,WP2)) vs Freq on SingleFreq_20_5GHz : Int

design cpw6_2 (HFSS, DrivenModal, model units mm)
geometry:
  trace_c1_path = polyline(z=0, xy: (-0.001, 0) (-0.0005, 0) (-0.0005, 0.00055365046) (-0.00025, 0.00055365046) (-0.00025, -0.00055365046) (0, -0.00055365046) (0, 0.00055365046) (0.00025, 0.00055365046) (0.00025, -0.00055365046) (0.0005, -0.00055365046) (0.0005, 0) (0.001, 0))
  trace_c1_path.fillet(Vertices=trace_c1_path.vertex(2 of 12, 3 of 12, 4 of 12, 5 of 12, 6 of 12, 7 of 12, 8 of 12, 9 of 12, 10 of 12, 11 of 12) Radius=0.0001 Setback=0mm)
  trace_c1 = polyline((-0.001, 5e-06, 0) (-0.001, -5e-06, 0))
  trace_c1.sweep_along_path(trace_c1_path)
  cut_c1_path = polyline(z=0, xy: (-0.001, 0) (-0.0005, 0) (-0.0005, 0.00055365046) (-0.00025, 0.00055365046) (-0.00025, -0.00055365046) (0, -0.00055365046) (0, 0.00055365046) (0.00025, 0.00055365046) (0.00025, -0.00055365046) (0.0005, -0.00055365046) (0.0005, 0) (0.001, 0))
  cut_c1_path.fillet(Vertices=cut_c1_path.vertex(2 of 12, 3 of 12, 4 of 12, 5 of 12, 6 of 12, 7 of 12, 8 of 12, 9 of 12, 10 of 12, 11 of 12) Radius=0.0001 Setback=0mm)
  cut_c1 = polyline((-0.001, 1.1e-05, 0) (-0.001, -1.1e-05, 0))
  cut_c1.sweep_along_path(cut_c1_path)
  g_wb [pec] = bondwire(WireType=LOW WireDiameter=0.015mm NumSides=6 XPadPos=-0.00075 YPadPos=-5.5e-05 ZPadPos=0 XDir=0 YDir=1 ZDir=0 Distance=0.00011 h1=0.00011 h2=0mm alpha=80deg beta=80deg WhichAxis=Z)
  g_wb_1 [pec] = bondwire(WireType=LOW WireDiameter=0.015mm NumSides=6 XPadPos=-0.000445 YPadPos=0.00027682523 ZPadPos=0 XDir=-1 YDir=0 ZDir=0 Distance=0.00011 h1=0.00011 h2=0mm alpha=80deg beta=80deg WhichAxis=Z)
  g_wb_2 [pec] = bondwire(WireType=LOW WireDiameter=0.015mm NumSides=6 XPadPos=-0.000305 YPadPos=0.00018455015 ZPadPos=0 XDir=1 YDir=0 ZDir=0 Distance=0.00011 h1=0.00011 h2=0mm alpha=80deg beta=80deg WhichAxis=Z)
  g_wb_3 [pec] = bondwire(WireType=LOW WireDiameter=0.015mm NumSides=6 XPadPos=-0.000305 YPadPos=-0.00018455015 ZPadPos=0 XDir=1 YDir=0 ZDir=0 Distance=0.00011 h1=0.00011 h2=0mm alpha=80deg beta=80deg WhichAxis=Z)
  g_wb_4 [pec] = bondwire(WireType=LOW WireDiameter=0.015mm NumSides=6 XPadPos=5.5e-05 YPadPos=-0.00018455015 ZPadPos=0 XDir=-1 YDir=0 ZDir=0 Distance=0.00011 h1=0.00011 h2=0mm alpha=80deg beta=80deg WhichAxis=Z)
  g_wb_5 [pec] = bondwire(WireType=LOW WireDiameter=0.015mm NumSides=6 XPadPos=5.5e-05 YPadPos=0.00018455015 ZPadPos=0 XDir=-1 YDir=0 ZDir=0 Distance=0.00011 h1=0.00011 h2=0mm alpha=80deg beta=80deg WhichAxis=Z)
  g_wb_6 [pec] = bondwire(WireType=LOW WireDiameter=0.015mm NumSides=6 XPadPos=0.000195 YPadPos=0.00018455015 ZPadPos=0 XDir=1 YDir=0 ZDir=0 Distance=0.00011 h1=0.00011 h2=0mm alpha=80deg beta=80deg WhichAxis=Z)
  g_wb_7 [pec] = bondwire(WireType=LOW WireDiameter=0.015mm NumSides=6 XPadPos=0.000195 YPadPos=-0.00018455015 ZPadPos=0 XDir=1 YDir=0 ZDir=0 Distance=0.00011 h1=0.00011 h2=0mm alpha=80deg beta=80deg WhichAxis=Z)
  g_wb_8 [pec] = bondwire(WireType=LOW WireDiameter=0.015mm NumSides=6 XPadPos=0.000555 YPadPos=-0.00027682523 ZPadPos=0 XDir=-1 YDir=0 ZDir=0 Distance=0.00011 h1=0.00011 h2=0mm alpha=80deg beta=80deg WhichAxis=Z)
  g_wb_9 [pec] = bondwire(WireType=LOW WireDiameter=0.015mm NumSides=6 XPadPos=0.00075 YPadPos=-5.5e-05 ZPadPos=0 XDir=0 YDir=1 ZDir=0 Distance=0.00011 h1=0.00011 h2=0mm alpha=80deg beta=80deg WhichAxis=Z)
  ground_main_plane = rectangle(corner=(-0.001, -0.001, 0), x_size=0.002, y_size=0.002)
  main [silicon] = box(corner=(-0.001, -0.001, -0.00075), size=(0.002, 0.002, 0.00075))
  sample_holder [vacuum] = box(corner=(-0.001, -0.001, -0.00165), size=(0.002, 0.002, 0.00254))
  ground_main_plane.subtract(cut_c1)
  WP1 = rectangle(corner=(-0.001, -0.0005, -0.0005), y_size=0.001, z_size=0.001)
  WP2 = rectangle(corner=(0.001, -0.0005, -0.0005), y_size=0.001, z_size=0.001)
boundaries and excitations:
  PerfE: Perfect E Objects=[trace_c1, ground_main_plane]
  WP1: Wave Port Objects=WP1 NumModes=1 Modes{Mode1{IntLine{middle of main.edge(3 of 12) -> ground_main_plane.vertex(#1322)} CharImp=Zpi RenormImp=50ohm}}
  WP2: Wave Port Objects=WP2 NumModes=1 Modes{Mode1{IntLine{middle of main.edge(1 of 12) -> ground_main_plane.vertex(#1298)} CharImp=Zpi RenormImp=50ohm}}
mesh:
  cpw: LengthBased Objects=trace_c1 MaxLength=0.005mm
setups:
  SingleFreq_20_5GHz: HfssDriven Frequency=20.5GHz MaxDeltaS=0.01 MaximumPasses=15 MinimumPasses=1 MinimumConvergedPasses=1 PercentRefinement=30 BasisOrder=1 PortAccuracy=2
    sweep Int: 500MHz to 20.5GHz, 25000 points; Type=Interpolating InterpTolerance=0.5 InterpMaxSolns=250 InterpUsePortImped=false PassivityErrorTolerance=0.0001
source amplitudes:
  WP1:1: 1W 0deg
  WP2:1: 0W 0deg
field plots:
  Mesh1: MeshPlots over ground_main_plane.face(all 2) trace_c1.face WP1.face WP2.face on SingleFreq_20_5GHz : LastAdaptive at Freq=20.5GHz Phase=0deg
  Mesh2: MeshPlots over ground_main_plane.face(all 2) trace_c1.face on SingleFreq_20_5GHz : LastAdaptive at Freq=20.5GHz Phase=0deg
reports:
  S Parameter Plot 1: dB(S(WP1,WP1)), dB(S(WP2,WP1)), dB(S(WP1,WP2)), dB(S(WP2,WP2)) vs Freq on SingleFreq_20_5GHz : Int
  Z Parameter Plot 1: dB20(Z(WP1,WP1)), dB20(Z(WP2,WP1)), dB20(Z(WP1,WP2)), dB20(Z(WP2,WP2)) vs Freq on SingleFreq_20_5GHz : Int; markers MX1 at x=9.8583067e+09
  Passivity Plot 1: Passivity vs Freq on SingleFreq_20_5GHz : Int
  Z Parameter Plot 2: im(Z(WP1,WP1)), im(Z(WP2,WP1)), im(Z(WP1,WP2)), im(Z(WP2,WP2)) vs Freq on SingleFreq_20_5GHz : Int
  Passivity Plot 2: Passivity vs Freq on SingleFreq_20_5GHz : Int

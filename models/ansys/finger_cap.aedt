# Ansys Electronics Desktop project, version 2021.2
materials:
  vacuum: permittivity=1
  silicon: permittivity=11.9
  copper: permeability=0.999991 conductivity=58000000
  perfect conductor: conductivity=1e+30
  pec: conductivity=1e+30

design finger_cap (HFSS, DrivenModal, model units mm)
geometry:
  trace_cpw1_path = polyline((-0.001, 0, 0) (-7.75e-05, 0, 0))
  trace_cpw1 = polyline((-0.001, 5e-06, 0) (-0.001, -5e-06, 0))
  trace_cpw1.sweep_along_path(trace_cpw1_path)
  cut_cpw1_path = polyline((-0.001, 0, 0) (-7.75e-05, 0, 0))
  cut_cpw1 = polyline((-0.001, 1.1e-05, 0) (-0.001, -1.1e-05, 0))
  cut_cpw1.sweep_along_path(cut_cpw1_path)
  trace_cpw2_path = polyline((7.75e-05, 0, 0) (0.001, 0, 0))
  trace_cpw2 = polyline((7.75e-05, 5e-06, 0) (7.75e-05, -5e-06, 0))
  trace_cpw2.sweep_along_path(trace_cpw2_path)
  cut_cpw2_path = polyline((7.75e-05, 0, 0) (0.001, 0, 0))
  cut_cpw2 = polyline((7.75e-05, 1.1e-05, 0) (7.75e-05, -1.1e-05, 0))
  cut_cpw2.sweep_along_path(cut_cpw2_path)
  pad_top_CAP1 = rectangle(corner=(-4.75e-05, -2.5e-05, 0), x_size=1e-05, y_size=5e-05)
  pad_bot_CAP1 = rectangle(corner=(3.75e-05, -2.5e-05, 0), x_size=1e-05, y_size=5e-05)
  cent_finger_CAP1 = rectangle(corner=(-3.75e-05, -5e-06, 0), x_size=6.5e-05, y_size=1e-05)
  left_finger_CAP1 = rectangle(corner=(-2.75e-05, -2.5e-05, 0), x_size=6.5e-05, y_size=1e-05)
  right_finger_CAP1 = rectangle(corner=(-2.75e-05, 1.5e-05, 0), x_size=6.5e-05, y_size=1e-05)
  trace_top_CAP1 = rectangle(corner=(-7.75e-05, -5e-06, 0), x_size=3e-05, y_size=1e-05)
  trace_bot_CAP1 = rectangle(corner=(4.75e-05, -5e-06, 0), x_size=3e-05, y_size=1e-05)
  pocket_CAP1 = rectangle(corner=(-7.75e-05, -3.5e-05, 0), x_size=0.000155, y_size=7e-05)
  ground_main_plane = rectangle(corner=(-0.001, -0.001, 0), x_size=0.002, y_size=0.002)
  main [silicon] = box(corner=(-0.001, -0.001, -0.00075), size=(0.002, 0.002, 0.00075))
  sample_holder [vacuum] = box(corner=(-0.001, -0.001, -0.00165), size=(0.002, 0.002, 0.00254))
  ground_main_plane.subtract(cut_cpw1, cut_cpw2, pocket_CAP1)
  WP1 = rectangle(corner=(-0.001, -0.0005, -0.0005), y_size=0.001, z_size=0.001)
  WP2 = rectangle(corner=(0.001, -0.0005, -0.0005), y_size=0.001, z_size=0.001)
boundaries and excitations:
  PerfE: Perfect E Objects=[trace_cpw1, trace_cpw2, pad_top_CAP1, pad_bot_CAP1, cent_finger_CAP1, left_finger_CAP1, right_finger_CAP1, trace_top_CAP1, trace_bot_CAP1, ground_main_plane]
  WP1: Wave Port Objects=WP1 NumModes=1 Modes{Mode1{IntLine{middle of main.edge(3 of 12) -> ground_main_plane.vertex(#259)} CharImp=Zpi RenormImp=50ohm}}
  WP2: Wave Port Objects=WP2 NumModes=1 Modes{Mode1{IntLine{middle of main.edge(1 of 12) -> ground_main_plane.vertex(#263)} CharImp=Zpi RenormImp=50ohm}}
mesh:
  cpw: LengthBased Objects=[cent_finger_CAP1, left_finger_CAP1, pad_bot_CAP1, pad_top_CAP1, right_finger_CAP1, trace_bot_CAP1, trace_cpw1, trace_cpw2, trace_top_CAP1] MaxLength=0.005mm
setups:
  SingleFreq_20_5GHz: HfssDriven Frequency=20.5GHz MaxDeltaS=0.01 MaximumPasses=15 MinimumPasses=1 MinimumConvergedPasses=1 PercentRefinement=30 BasisOrder=1 PortAccuracy=2
    sweep Int: 500MHz to 20.5GHz, 25000 points; Type=Interpolating InterpTolerance=0.5 InterpMaxSolns=250 InterpUsePortImped=false PassivityErrorTolerance=0.0001
source amplitudes:
  WP1:1: 1W 0deg
  WP2:1: 0W 0deg
field plots:
  Mag_E1: E Field over WP1.face WP2.face on SingleFreq_20_5GHz : LastAdaptive at Freq=20.5GHz Phase=0deg
  Mesh1: MeshPlots over cent_finger_CAP1.face ground_main_plane.face(all 2) left_finger_CAP1.face pad_bot_CAP1.face pad_top_CAP1.face right_finger_CAP1.face trace_bot_CAP1.face trace_cpw1.face trace_cpw2.face trace_top_CAP1.face WP1.face WP2.face on SingleFreq_20_5GHz : LastAdaptive at Freq=20.5GHz Phase=0deg
reports:
  S Parameter Plot 1: dB(S(WP1,WP1)), dB(S(WP2,WP1)), dB(S(WP1,WP2)), dB(S(WP2,WP2)) vs Freq on SingleFreq_20_5GHz : Int
  Z Parameter Plot 1: dB20(Z(WP1,WP1)), dB20(Z(WP2,WP1)), dB20(Z(WP1,WP2)), dB20(Z(WP2,WP2)) vs Freq on SingleFreq_20_5GHz : Int; markers MX1 at x=9.9987746e+08

# Ansys Electronics Desktop project, version 2021.2
materials:
  vacuum: permittivity=1
  pec: conductivity=1e+30
  silicon: permittivity=11.9
  copper: permeability=0.999991 conductivity=58000000
  perfect conductor: conductivity=1e+30

design transmon2 (HFSS, DrivenModal, model units mm)
geometry:
  q_couple1_wire_Q1_path = polyline(z=0, xy: (-0.0002125, 0.000124) (-0.0002375, 0.000124) (-0.00032, 0.000189) (-0.000425, 0.000189))
  q_couple1_wire_Q1 = polyline((-0.0002125, 0.000119, 0) (-0.0002125, 0.000129, 0))
  q_couple1_wire_Q1.sweep_along_path(q_couple1_wire_Q1_path)
  q_couple1_wire_sub_Q1_path = polyline(z=0, xy: (-0.0002125, 0.000124) (-0.0002375, 0.000124) (-0.00032, 0.000189) (-0.000425, 0.000189))
  q_couple1_wire_sub_Q1 = polyline((-0.0002125, 0.000113, 0) (-0.0002125, 0.000135, 0))
  q_couple1_wire_sub_Q1.sweep_along_path(q_couple1_wire_sub_Q1_path)
  q_couple2_wire_Q1_path = polyline(z=0, xy: (0.0002125, 0.000124) (0.0002375, 0.000124) (0.00032, 0.000189) (0.000425, 0.000189))
  q_couple2_wire_Q1 = polyline((0.0002125, 0.000129, 0) (0.0002125, 0.000119, 0))
  q_couple2_wire_Q1.sweep_along_path(q_couple2_wire_Q1_path)
  q_couple2_wire_sub_Q1_path = polyline(z=0, xy: (0.0002125, 0.000124) (0.0002375, 0.000124) (0.00032, 0.000189) (0.000425, 0.000189))
  q_couple2_wire_sub_Q1 = polyline((0.0002125, 0.000135, 0) (0.0002125, 0.000113, 0))
  q_couple2_wire_sub_Q1.sweep_along_path(q_couple2_wire_sub_Q1_path)
  q_couple3_wire_Q1_path = polyline(z=0, xy: (0.0002125, -0.000124) (0.0002375, -0.000124) (0.00032, -0.000189) (0.000425, -0.000189))
  q_couple3_wire_Q1 = polyline((0.0002125, -0.000119, 0) (0.0002125, -0.000129, 0))
  q_couple3_wire_Q1.sweep_along_path(q_couple3_wire_Q1_path)
  q_couple3_wire_sub_Q1_path = polyline(z=0, xy: (0.0002125, -0.000124) (0.0002375, -0.000124) (0.00032, -0.000189) (0.000425, -0.000189))
  q_couple3_wire_sub_Q1 = polyline((0.0002125, -0.000113, 0) (0.0002125, -0.000135, 0))
  q_couple3_wire_sub_Q1.sweep_along_path(q_couple3_wire_sub_Q1_path)
  q_couple4_wire_Q1_path = polyline(z=0, xy: (-0.0002125, -0.000124) (-0.0002375, -0.000124) (-0.00032, -0.000189) (-0.000425, -0.000189))
  q_couple4_wire_Q1 = polyline((-0.0002125, -0.000129, 0) (-0.0002125, -0.000119, 0))
  q_couple4_wire_Q1.sweep_along_path(q_couple4_wire_Q1_path)
  q_couple4_wire_sub_Q1_path = polyline(z=0, xy: (-0.0002125, -0.000124) (-0.0002375, -0.000124) (-0.00032, -0.000189) (-0.000425, -0.000189))
  q_couple4_wire_sub_Q1 = polyline((-0.0002125, -0.000135, 0) (-0.0002125, -0.000113, 0))
  q_couple4_wire_sub_Q1.sweep_along_path(q_couple4_wire_sub_Q1_path)
  trace_cpw1_path = polyline(z=0, xy: (-0.000425, 0.000189) (-0.00052, 0.000189) (-0.00052, 0.000539325) (-0.00075, 0.000539325) (-0.00075, 0) (-0.001, 0))
  trace_cpw1_path.fillet(Vertices=trace_cpw1_path.vertex(2 of 6, 3 of 6, 4 of 6, 5 of 6) Radius=9e-05 Setback=0mm)
  trace_cpw1 = polyline((-0.000425, 0.000184, 0) (-0.000425, 0.000194, 0))
  trace_cpw1.sweep_along_path(trace_cpw1_path)
  cut_cpw1_path = polyline(z=0, xy: (-0.000425, 0.000189) (-0.00052, 0.000189) (-0.00052, 0.000539325) (-0.00075, 0.000539325) (-0.00075, 0) (-0.001, 0))
  cut_cpw1_path.fillet(Vertices=cut_cpw1_path.vertex(2 of 6, 3 of 6, 4 of 6, 5 of 6) Radius=9e-05 Setback=0mm)
  cut_cpw1 = polyline((-0.000425, 0.000178, 0) (-0.000425, 0.0002, 0))
  cut_cpw1.sweep_along_path(cut_cpw1_path)
  trace_cpw2_path = polyline(z=0, xy: (0.000425, 0.000189) (0.00052, 0.000189) (0.00052, 0.0006) (0, 0.0006) (0, 0.001))
  trace_cpw2_path.fillet(Vertices=trace_cpw2_path.vertex(2 of 5, 3 of 5, 4 of 5) Radius=9e-05 Setback=0mm)
  trace_cpw2 = polyline((0.000425, 0.000194, 0) (0.000425, 0.000184, 0))
  trace_cpw2.sweep_along_path(trace_cpw2_path)
  cut_cpw2_path = polyline(z=0, xy: (0.000425, 0.000189) (0.00052, 0.000189) (0.00052, 0.0006) (0, 0.0006) (0, 0.001))
  cut_cpw2_path.fillet(Vertices=cut_cpw2_path.vertex(2 of 5, 3 of 5, 4 of 5) Radius=9e-05 Setback=0mm)
  cut_cpw2 = polyline((0.000425, 0.0002, 0) (0.000425, 0.000178, 0))
  cut_cpw2.sweep_along_path(cut_cpw2_path)
  trace_cpw3_path = polyline(z=0, xy: (0.000425, -0.000189) (0.00052, -0.000189) (0.00052, -0.000539325) (0.00075, -0.000539325) (0.00075, 0) (0.001, 0))
  trace_cpw3_path.fillet(Vertices=trace_cpw3_path.vertex(2 of 6, 3 of 6, 4 of 6, 5 of 6) Radius=9e-05 Setback=0mm)
  trace_cpw3 = polyline((0.000425, -0.000184, 0) (0.000425, -0.000194, 0))
  trace_cpw3.sweep_along_path(trace_cpw3_path)
  cut_cpw3_path = polyline(z=0, xy: (0.000425, -0.000189) (0.00052, -0.000189) (0.00052, -0.000539325) (0.00075, -0.000539325) (0.00075, 0) (0.001, 0))
  cut_cpw3_path.fillet(Vertices=cut_cpw3_path.vertex(2 of 6, 3 of 6, 4 of 6, 5 of 6) Radius=9e-05 Setback=0mm)
  cut_cpw3 = polyline((0.000425, -0.000178, 0) (0.000425, -0.0002, 0))
  cut_cpw3.sweep_along_path(cut_cpw3_path)
  trace_cpw4_path = polyline(z=0, xy: (-0.000425, -0.000189) (-0.00052, -0.000189) (-0.00052, -0.0006) (0, -0.0006) (0, -0.001))
  trace_cpw4_path.fillet(Vertices=trace_cpw4_path.vertex(2 of 5, 3 of 5, 4 of 5) Radius=9e-05 Setback=0mm)
  trace_cpw4 = polyline((-0.000425, -0.000194, 0) (-0.000425, -0.000184, 0))
  trace_cpw4.sweep_along_path(trace_cpw4_path)
  cut_cpw4_path = polyline(z=0, xy: (-0.000425, -0.000189) (-0.00052, -0.000189) (-0.00052, -0.0006) (0, -0.0006) (0, -0.001))
  cut_cpw4_path.fillet(Vertices=cut_cpw4_path.vertex(2 of 5, 3 of 5, 4 of 5) Radius=9e-05 Setback=0mm)
  cut_cpw4 = polyline((-0.000425, -0.0002, 0) (-0.000425, -0.000178, 0))
  cut_cpw4.sweep_along_path(cut_cpw4_path)
  g_wb [pec] = bondwire(WireType=LOW WireDiameter=0.015mm NumSides=6 XPadPos=-0.000805 YPadPos=0.0002696625 ZPadPos=0 XDir=1 YDir=0 ZDir=0 Distance=0.00011 h1=0.00011 h2=0mm alpha=80deg beta=80deg WhichAxis=Z)
  g_wb_1 [pec] = bondwire(WireType=LOW WireDiameter=0.015mm NumSides=6 XPadPos=0.000575 YPadPos=0.0003945 ZPadPos=0 XDir=-1 YDir=0 ZDir=0 Distance=0.00011 h1=0.00011 h2=0mm alpha=80deg beta=80deg WhichAxis=Z)
  g_wb_2 [pec] = bondwire(WireType=LOW WireDiameter=0.015mm NumSides=6 XPadPos=0.00026 YPadPos=0.000655 ZPadPos=0 XDir=0 YDir=-1 ZDir=0 Distance=0.00011 h1=0.00011 h2=0mm alpha=80deg beta=80deg WhichAxis=Z)
  g_wb_3 [pec] = bondwire(WireType=LOW WireDiameter=0.015mm NumSides=6 XPadPos=5.5e-05 YPadPos=0.0008 ZPadPos=0 XDir=-1 YDir=0 ZDir=0 Distance=0.00011 h1=0.00011 h2=0mm alpha=80deg beta=80deg WhichAxis=Z)
  g_wb_4 [pec] = bondwire(WireType=LOW WireDiameter=0.015mm NumSides=6 XPadPos=0.000805 YPadPos=-0.0002696625 ZPadPos=0 XDir=-1 YDir=0 ZDir=0 Distance=0.00011 h1=0.00011 h2=0mm alpha=80deg beta=80deg WhichAxis=Z)
  g_wb_5 [pec] = bondwire(WireType=LOW WireDiameter=0.015mm NumSides=6 XPadPos=-0.000575 YPadPos=-0.0003945 ZPadPos=0 XDir=1 YDir=0 ZDir=0 Distance=0.00011 h1=0.00011 h2=0mm alpha=80deg beta=80deg WhichAxis=Z)
  g_wb_6 [pec] = bondwire(WireType=LOW WireDiameter=0.015mm NumSides=6 XPadPos=-0.00026 YPadPos=-0.000655 ZPadPos=0 XDir=0 YDir=1 ZDir=0 Distance=0.00011 h1=0.00011 h2=0mm alpha=80deg beta=80deg WhichAxis=Z)
  g_wb_7 [pec] = bondwire(WireType=LOW WireDiameter=0.015mm NumSides=6 XPadPos=-5.5e-05 YPadPos=-0.0008 ZPadPos=0 XDir=1 YDir=0 ZDir=0 Distance=0.00011 h1=0.00011 h2=0mm alpha=80deg beta=80deg WhichAxis=Z)
  pad_top_Q1 = rectangle(corner=(-0.0002125, 1.4e-05, 0), x_size=0.000425, y_size=9e-05)
  pad_bot_Q1 = rectangle(corner=(-0.0002125, -0.000104, 0), x_size=0.000425, y_size=9e-05)
  rect_pk_Q1 = rectangle(corner=(-0.000325, -0.000325, 0), x_size=0.00065, y_size=0.00065)
  q_couple1_connector_pad_Q1 = rectangle(corner=(-0.0002125, 0.000114, 0), x_size=0.0001, y_size=2.2e-05)
  q_couple2_connector_pad_Q1 = rectangle(corner=(0.0001125, 0.000114, 0), x_size=0.0001, y_size=2.2e-05)
  q_couple3_connector_pad_Q1 = rectangle(corner=(0.0001125, -0.000136, 0), x_size=0.0001, y_size=2.2e-05)
  q_couple4_connector_pad_Q1 = rectangle(corner=(-0.0002125, -0.000136, 0), x_size=0.0001, y_size=2.2e-05)
  JJ1 = rectangle(corner=(-5e-06, -1.4e-05, 0), x_size=1e-05, y_size=2.8e-05)
  ground_main_plane = rectangle(corner=(-0.001, -0.001, 0), x_size=0.002, y_size=0.002)
  main [silicon] = box(corner=(-0.001, -0.001, -0.00075), size=(0.002, 0.002, 0.00075))
  sample_holder [vacuum] = box(corner=(-0.001, -0.001, -0.00165), size=(0.002, 0.002, 0.00254))
  ground_main_plane.subtract(q_couple2_wire_sub_Q1, rect_pk_Q1, cut_cpw4, q_couple1_wire_sub_Q1, cut_cpw3, cut_cpw1, q_couple3_wire_sub_Q1, q_couple4_wire_sub_Q1, cut_cpw2)
  WP1 = rectangle(corner=(-0.001, -0.0005, -0.00025), y_size=0.001, z_size=0.0005)
  WP2 = rectangle(corner=(-0.0005, 0.001, -0.00025), z_size=0.0005, x_size=0.001)
  WP3 = rectangle(corner=(0.001, -0.0005, -0.00025), y_size=0.001, z_size=0.0005)
  WP4 = rectangle(corner=(-0.0005, -0.001, -0.00025), z_size=0.0005, x_size=0.001)
boundaries and excitations:
  PerfE: Perfect E Objects=[q_couple1_wire_Q1, q_couple2_wire_Q1, q_couple3_wire_Q1, q_couple4_wire_Q1, trace_cpw1..trace_cpw4, pad_top_Q1, pad_bot_Q1, q_couple1_connector_pad_Q1, q_couple2_connector_pad_Q1, q_couple3_connector_pad_Q1, q_couple4_connector_pad_Q1, ground_main_plane]
  JJ1: Lumped Port Objects=JJ1 Modes{Mode1{IntLine{middle of JJ1.edge(y at corner) -> middle of JJ1.edge(y opposite corner)} CharImp=Zpi RenormImp=50ohm}} Impedance=50ohm
  WP1: Wave Port Objects=WP1 NumModes=1 Modes{Mode1{IntLine{middle of main.edge(3 of 12) -> ground_main_plane.vertex(#1761)} CharImp=Zpi RenormImp=50ohm}}
  WP2: Wave Port Objects=WP2 NumModes=1 Modes{Mode1{IntLine{middle of main.edge(2 of 12) -> ground_main_plane.vertex(#1741)} CharImp=Zpi RenormImp=50ohm}}
  WP3: Wave Port Objects=WP3 NumModes=1 Modes{Mode1{IntLine{middle of main.edge(1 of 12) -> ground_main_plane.vertex(#1729)} CharImp=Zpi RenormImp=50ohm}}
  WP4: Wave Port Objects=WP4 NumModes=1 Modes{Mode1{IntLine{middle of main.edge(4 of 12) -> ground_main_plane.vertex(#1715)} CharImp=Zpi RenormImp=50ohm}}
mesh:
  cpw: LengthBased Objects=[q_couple1_connector_pad_Q1, q_couple1_wire_Q1, q_couple2_connector_pad_Q1, q_couple2_wire_Q1, q_couple3_connector_pad_Q1, q_couple3_wire_Q1, q_couple4_connector_pad_Q1, q_couple4_wire_Q1, trace_cpw1..trace_cpw4] MaxLength=0.005mm
setups:
  SingleFreq_20_5GHz: HfssDriven Frequency=20.5GHz MaxDeltaS=0.01 MaximumPasses=15 MinimumPasses=1 MinimumConvergedPasses=1 PercentRefinement=30 BasisOrder=1 PortAccuracy=2
    sweep Int: 500MHz to 20.5GHz, 25000 points; Type=Interpolating InterpTolerance=0.5 InterpMaxSolns=250 InterpUsePortImped=false PassivityErrorTolerance=0.0001
source amplitudes:
  JJ1:1: 1W 0deg
  WP1:1, WP2:1, WP3:1, WP4:1: 0W 0deg
field plots:
  Mesh1: MeshPlots over ground_main_plane.face(all 4) pad_bot_Q1.face pad_top_Q1.face q_couple1_connector_pad_Q1.face q_couple1_wire_Q1.face q_couple2_connector_pad_Q1.face q_couple2_wire_Q1.face q_couple3_connector_pad_Q1.face q_couple3_wire_Q1.face q_couple4_connector_pad_Q1.face q_couple4_wire_Q1.face trace_cpw1.face trace_cpw2.face trace_cpw3.face trace_cpw4.face on SingleFreq_20_5GHz : LastAdaptive at Freq=20.5GHz Phase=0deg
reports:
  S Parameter Plot 1: dB(S(JJ1,JJ1)), dB(S(WP1,JJ1)), dB(S(WP2,JJ1)), dB(S(WP3,JJ1)), dB(S(WP4,JJ1)), dB(S(JJ1,WP1)), dB(S(WP1,WP1)), dB(S(WP2,WP1)), dB(S(WP3,WP1)), dB(S(WP4,WP1)), dB(S(JJ1,WP2)), dB(S(WP1,WP2)), dB(S(WP2,WP2)), dB(S(WP3,WP2)), dB(S(WP4,WP2)), dB(S(JJ1,WP3)), dB(S(WP1,WP3)), dB(S(WP2,WP3)), dB(S(WP3,WP3)), dB(S(WP4,WP3)), dB(S(JJ1,WP4)), dB(S(WP1,WP4)), dB(S(WP2,WP4)), dB(S(WP3,WP4)), dB(S(WP4,WP4)) vs Freq on SingleFreq_20_5GHz : Int; markers MX1 at x=2.5025867e+09
  Passivity Plot 1: Passivity vs Freq on SingleFreq_20_5GHz : Int
  Z Parameter Plot 1: dB20(Z(JJ1,JJ1)), dB20(Z(WP1,JJ1)), dB20(Z(WP2,JJ1)), dB20(Z(WP3,JJ1)), dB20(Z(WP4,JJ1)), dB20(Z(JJ1,WP1)), dB20(Z(WP1,WP1)), dB20(Z(WP2,WP1)), dB20(Z(WP3,WP1)), dB20(Z(WP4,WP1)), dB20(Z(JJ1,WP2)), dB20(Z(WP1,WP2)), dB20(Z(WP2,WP2)), dB20(Z(WP3,WP2)), dB20(Z(WP4,WP2)), dB20(Z(JJ1,WP3)), dB20(Z(WP1,WP3)), dB20(Z(WP2,WP3)), dB20(Z(WP3,WP3)), dB20(Z(WP4,WP3)), dB20(Z(JJ1,WP4)), dB20(Z(WP1,WP4)), dB20(Z(WP2,WP4)), dB20(Z(WP3,WP4)), dB20(Z(WP4,WP4)) vs Freq on SingleFreq_20_5GHz : Int
  Z Parameter Plot 2: dB20(Z(JJ1,JJ1)), dB20(Z(WP1,JJ1)), dB20(Z(WP2,JJ1)), dB20(Z(WP3,JJ1)), dB20(Z(WP4,JJ1)), dB20(Z(JJ1,WP1)), dB20(Z(WP1,WP1)), dB20(Z(WP2,WP1)), dB20(Z(WP3,WP1)), dB20(Z(WP4,WP1)), dB20(Z(JJ1,WP2)), dB20(Z(WP1,WP2)), dB20(Z(WP2,WP2)), dB20(Z(WP3,WP2)), dB20(Z(WP4,WP2)), dB20(Z(JJ1,WP3)), dB20(Z(WP1,WP3)), dB20(Z(WP2,WP3)), dB20(Z(WP3,WP3)), dB20(Z(WP4,WP3)), dB20(Z(JJ1,WP4)), dB20(Z(WP1,WP4)), dB20(Z(WP2,WP4)), dB20(Z(WP3,WP4)), dB20(Z(WP4,WP4)) vs Freq on SingleFreq_20_5GHz : Int
  Z Parameter Plot 3: im(Z(JJ1,JJ1)), im(Z(WP1,JJ1)), im(Z(WP2,JJ1)), im(Z(WP3,JJ1)), im(Z(WP4,JJ1)), im(Z(JJ1,WP1)), im(Z(WP1,WP1)), im(Z(WP2,WP1)), im(Z(WP3,WP1)), im(Z(WP4,WP1)), im(Z(JJ1,WP2)), im(Z(WP1,WP2)), im(Z(WP2,WP2)), im(Z(WP3,WP2)), im(Z(WP4,WP2)), im(Z(JJ1,WP3)), im(Z(WP1,WP3)), im(Z(WP2,WP3)), im(Z(WP3,WP3)), im(Z(WP4,WP3)), im(Z(JJ1,WP4)), im(Z(WP1,WP4)), im(Z(WP2,WP4)), im(Z(WP3,WP4)), im(Z(WP4,WP4)) vs Freq on SingleFreq_20_5GHz : Int

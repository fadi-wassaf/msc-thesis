# Ansys Electronics Desktop project, version 2021.2
materials:
  vacuum: permittivity=1
  pec: conductivity=1e+30
  silicon: permittivity=11.9

design tcouple (HFSS, DrivenModal, model units mm)
geometry:
  prime_cpw_CLT_path = polyline((-0.0008, 0, 0) (0.0008, 0, 0))
  prime_cpw_CLT = polyline((-0.0008, 5e-06, 0) (-0.0008, -5e-06, 0))
  prime_cpw_CLT.sweep_along_path(prime_cpw_CLT_path)
  prime_cpw_sub_CLT_path = polyline((-0.0008, 0, 0) (0.0008, 0, 0))
  prime_cpw_sub_CLT = polyline((-0.0008, 1.1e-05, 0) (-0.0008, -1.1e-05, 0))
  prime_cpw_sub_CLT.sweep_along_path(prime_cpw_sub_CLT_path)
  second_cpw_CLT_path = polyline(z=0, xy: (-0.0004, -2.5e-05) (0.0004, -2.5e-05) (0.0004, -0.000175))
  second_cpw_CLT_path.fillet(Vertices=second_cpw_CLT_path.vertex(2 of 3) Radius=0.0001 Setback=0mm)
  second_cpw_CLT = polyline((-0.0004, -2e-05, 0) (-0.0004, -3e-05, 0))
  second_cpw_CLT.sweep_along_path(second_cpw_CLT_path)
  second_cpw_sub_CLT_path = polyline(z=0, xy: (-0.000406, -2.5e-05) (0.0004, -2.5e-05) (0.0004, -0.000175))
  second_cpw_sub_CLT_path.fillet(Vertices=second_cpw_sub_CLT_path.vertex(2 of 3) Radius=0.0001 Setback=0mm)
  second_cpw_sub_CLT = polyline((-0.000406, -1.4e-05, 0) (-0.000406, -3.6e-05, 0))
  second_cpw_sub_CLT.sweep_along_path(second_cpw_sub_CLT_path)
  trace_cpw1_path = polyline((-0.001, 0, 0) (-0.0008, 0, 0))
  trace_cpw1 = polyline((-0.001, 5e-06, 0) (-0.001, -5e-06, 0))
  trace_cpw1.sweep_along_path(trace_cpw1_path)
  cut_cpw1_path = polyline((-0.001, 0, 0) (-0.0008, 0, 0))
  cut_cpw1 = polyline((-0.001, 1.1e-05, 0) (-0.001, -1.1e-05, 0))
  cut_cpw1.sweep_along_path(cut_cpw1_path)
  trace_cpw2_path = polyline((0.0008, 0, 0) (0.001, 0, 0))
  trace_cpw2 = polyline((0.0008, 5e-06, 0) (0.0008, -5e-06, 0))
  trace_cpw2.sweep_along_path(trace_cpw2_path)
  cut_cpw2_path = polyline((0.0008, 0, 0) (0.001, 0, 0))
  cut_cpw2 = polyline((0.0008, 1.1e-05, 0) (0.0008, -1.1e-05, 0))
  cut_cpw2.sweep_along_path(cut_cpw2_path)
  trace_cpw3_path = polyline(z=0, xy: (0.0004, -0.000175) (0.0004, -0.0005) (0, -0.0005) (0, -0.001))
  trace_cpw3_path.fillet(Vertices=trace_cpw3_path.vertex(2 of 4, 3 of 4) Radius=0.0001 Setback=0mm)
  trace_cpw3 = polyline((0.000405, -0.000175, 0) (0.000395, -0.000175, 0))
  trace_cpw3.sweep_along_path(trace_cpw3_path)
  cut_cpw3_path = polyline(z=0, xy: (0.0004, -0.000175) (0.0004, -0.0005) (0, -0.0005) (0, -0.001))
  cut_cpw3_path.fillet(Vertices=cut_cpw3_path.vertex(2 of 4, 3 of 4) Radius=0.0001 Setback=0mm)
  cut_cpw3 = polyline((0.000411, -0.000175, 0) (0.000389, -0.000175, 0))
  cut_cpw3.sweep_along_path(cut_cpw3_path)
  g_wb [pec] = bondwire(WireType=LOW WireDiameter=0.015mm NumSides=6 XPadPos=-0.00048 YPadPos=-5.5e-05 ZPadPos=0 XDir=0 YDir=1 ZDir=0 Distance=0.00011 h1=0.00011 h2=0mm alpha=80deg beta=80deg WhichAxis=Z)
  g_wb_1 [pec] = bondwire(WireType=LOW WireDiameter=0.015mm NumSides=6 XPadPos=-0.00016 YPadPos=-5.5e-05 ZPadPos=0 XDir=0 YDir=1 ZDir=0 Distance=0.00011 h1=0.00011 h2=0mm alpha=80deg beta=80deg WhichAxis=Z)
  g_wb_2 [pec] = bondwire(WireType=LOW WireDiameter=0.015mm NumSides=6 XPadPos=0.00016 YPadPos=-5.5e-05 ZPadPos=0 XDir=0 YDir=1 ZDir=0 Distance=0.00011 h1=0.00011 h2=0mm alpha=80deg beta=80deg WhichAxis=Z)
  g_wb_3 [pec] = bondwire(WireType=LOW WireDiameter=0.015mm NumSides=6 XPadPos=0.00048 YPadPos=-5.5e-05 ZPadPos=0 XDir=0 YDir=1 ZDir=0 Distance=0.00011 h1=0.00011 h2=0mm alpha=80deg beta=80deg WhichAxis=Z)
  g_wb_6 [pec] = bondwire(WireType=LOW WireDiameter=0.015mm NumSides=6 XPadPos=0.0002 YPadPos=-0.000445 ZPadPos=0 XDir=0 YDir=-1 ZDir=0 Distance=0.00011 h1=0.00011 h2=0mm alpha=80deg beta=80deg WhichAxis=Z)
  g_wb_7 [pec] = bondwire(WireType=LOW WireDiameter=0.015mm NumSides=6 XPadPos=-5.5e-05 YPadPos=-0.00075 ZPadPos=0 XDir=1 YDir=0 ZDir=0 Distance=0.00011 h1=0.00011 h2=0mm alpha=80deg beta=80deg WhichAxis=Z)
  ground_main_plane = rectangle(corner=(-0.001, -0.001, 0), x_size=0.002, y_size=0.002)
  main [silicon] = box(corner=(-0.001, -0.001, -0.00075), size=(0.002, 0.002, 0.00075))
  sample_holder [vacuum] = box(corner=(-0.001, -0.001, -0.00165), size=(0.002, 0.002, 0.00254))
  ground_main_plane.subtract(prime_cpw_sub_CLT, cut_cpw1, cut_cpw2, second_cpw_sub_CLT, cut_cpw3)
  WP1 = rectangle(corner=(-0.001, -0.0005, -0.00025), y_size=0.001, z_size=0.0005)
  WP2 = rectangle(corner=(0.001, -0.0005, -0.00025), y_size=0.001, z_size=0.0005)
  WP3 = rectangle(corner=(-0.0005, -0.001, -0.00025), z_size=0.0005, x_size=0.001)
boundaries and excitations:
  PerfE: Perfect E Objects=[prime_cpw_CLT, second_cpw_CLT, trace_cpw1, trace_cpw2, trace_cpw3, ground_main_plane]
  WP1: Wave Port Objects=WP1 NumModes=1 Modes{Mode1{IntLine{middle of main.edge(3 of 12) -> ground_main_plane.vertex(#2179)} CharImp=Zpi RenormImp=50ohm}}
  WP2: Wave Port Objects=WP2 NumModes=1 Modes{Mode1{IntLine{middle of main.edge(1 of 12) -> ground_main_plane.vertex(#2163)} CharImp=Zpi RenormImp=50ohm}}
  WP3: Wave Port Objects=WP3 NumModes=1 Modes{Mode1{IntLine{middle of main.edge(4 of 12) -> ground_main_plane.vertex(#2165)} CharImp=Zpi RenormImp=50ohm}}
mesh:
  cpw: LengthBased Objects=[prime_cpw_CLT, second_cpw_CLT, trace_cpw1, trace_cpw2, trace_cpw3] MaxLength=0.005mm
setups:
  SingleFreq_20_5GHz: HfssDriven Frequency=20.5GHz MaxDeltaS=0.01 MaximumPasses=15 MinimumPasses=1 MinimumConvergedPasses=1 PercentRefinement=30 BasisOrder=1 PortAccuracy=2
    sweep Int: 500MHz to 20.5GHz, 25000 points; Type=Interpolating InterpTolerance=0.5 InterpMaxSolns=250 InterpUsePortImped=false PassivityErrorTolerance=0.0001
source amplitudes:
  WP1:1: 1W 0deg
  WP2:1, WP3:1: 0W 0deg
field plots:
  Mesh1: MeshPlots over ground_main_plane.face(all 2) prime_cpw_CLT.face second_cpw_CLT.face trace_cpw1.face trace_cpw2.face trace_cpw3.face on SingleFreq_20_5GHz : LastAdaptive at Freq=20.5GHz Phase=0deg
  Mesh2: MeshPlots over WP1.face WP2.face WP3.face on SingleFreq_20_5GHz : LastAdaptive at Freq=20.5GHz Phase=0deg
reports:
  S Parameter Plot 1: dB(S(WP1,WP1)), dB(S(WP2,WP1)), dB(S(WP3,WP1)), dB(S(WP1,WP2)), dB(S(WP2,WP2)), dB(S(WP3,WP2)), dB(S(WP1,WP3)), dB(S(WP2,WP3)), dB(S(WP3,WP3)) vs Freq on SingleFreq_20_5GHz : Int

# Ansys Electronics Desktop project, version 2021.2
materials:
  vacuum: permittivity=1
  pec: conductivity=1e+30
  silicon: permittivity=11.9

design cap_res_cap_eigenmode (HFSS, Eigenmode, model units mm)
geometry:
  trace_c1 = polyline((-0.001, 5e-06, 0) (-0.001, -5e-06, 0))
  trace_c1_path = polyline(z=0, xy: (-0.001, 0) (-0.0005, 0) (-0.0005, 0.00055365046) (-0.00025, 0.00055365046) (-0.00025, -0.00055365046) (0, -0.00055365046) (0, 0.00055365046) (0.00025, 0.00055365046) (0.00025, -0.00055365046) (0.0005, -0.00055365046) (0.0005, 0) (0.001, 0))
  trace_c1_path.fillet(Vertices=trace_c1_path.vertex(2 of 12, 3 of 12, 4 of 12, 5 of 12, 6 of 12, 7 of 12, 8 of 12, 9 of 12, 10 of 12, 11 of 12) Radius=0.0001 Setback=0mm)
  trace_c1.sweep_along_path(trace_c1_path)
  g_wb [pec] = bondwire(WireType=LOW WireDiameter=0.015mm NumSides=6 XPadPos=-0.00075 YPadPos=-5.5e-05 ZPadPos=0 XDir=0 YDir=1 ZDir=0 Distance=0.00011 h1=0.00011 h2=0mm alpha=80deg beta=80deg WhichAxis=Z)
  g_wb_1 [pec] = bondwire(WireType=LOW WireDiameter=0.015mm NumSides=6 XPadPos=-0.000445 YPadPos=0.00027682523 ZPadPos=0 XDir=-1 YDir=0 ZDir=0 Distance=0.00011 h1=0.00011 h2=0mm alpha=80deg beta=80deg WhichAxis=Z)
  g_wb_2 [pec] = bondwire(WireType=LOW WireDiameter=0.015mm NumSides=6 XPadPos=-0.000305 YPadPos=0.00018455015 ZPadPos=0 XDir=1 YDir=0 ZDir=0 Distance=0.00011 h1=0.00011 h2=0mm alpha=80deg beta=80deg WhichAxis=Z)
  g_wb_3 [pec] = bondwire(WireType=LOW WireDiameter=0.015mm NumSides=6 XPadPos=-0.000305 YPadPos=-0.00018455015 ZPadPos=0 XDir=1 YDir=0 ZDir=0 Distance=0.00011 h1=0.00011 h2=0mm alpha=80deg beta=80deg WhichAxis=Z)
  g_wb_4 [pec] = bondwire(WireType=LOW WireDiameter=0.015mm NumSides=6 XPadPos=5.5e-05 YPadPos=-0.00018455015 ZPadPos=0 XDir=-1 YDir=0 ZDir=0 Distance=0.00011 h1=0.00011 h2=0mm alpha=80deg beta=80deg WhichAxis=Z)
  g_wb_5 [pec] = bondwire(WireType=LOW WireDiameter=0.015mm NumSides=6 XPadPos=5.5e-05 YPadPos=0.00018455015 ZPadPos=0 XDir=-1 YDir=0 ZDir=0 Distance=0.00011 h1=0.00011 h2=0mm alpha=80deg beta=80deg WhichAxis=Z)
  g_wb_6 [pec] = bondwire(WireType=LOW WireDiameter=0.015mm NumSides=6 XPadPos=0.000195 YPadPos=0.00018455015 ZPadPos=0 XDir=1 YDir=0 ZDir=0 Distance=0.00011 h1=0.00011 h2=0mm alpha=80deg beta=80deg WhichAxis=Z)
  g_wb_7 [pec] = bondwire(WireType=LOW WireDiameter=0.015mm NumSides=6 XPadPos=0.000195 YPadPos=-0.00018455015 ZPadPos=0 XDir=1 YDir=0 ZDir=0 Distance=0.00011 h1=0.00011 h2=0mm alpha=80deg beta=80deg WhichAxis=Z)
  g_wb_8 [pec] = bondwire(WireType=LOW WireDiameter=0.015mm NumSides=6 XPadPos=0.000555 YPadPos=-0.00027682523 ZPadPos=0 XDir=-1 YDir=0 ZDir=0 Distance=0.00011 h1=0.00011 h2=0mm alpha=80deg beta=80deg WhichAxis=Z)
  g_wb_9 [pec] = bondwire(WireType=LOW WireDiameter=0.015mm NumSides=6 XPadPos=0.00075 YPadPos=-5.5e-05 ZPadPos=0 XDir=0 YDir=1 ZDir=0 Distance=0.00011 h1=0.00011 h2=0mm alpha=80deg beta=80deg WhichAxis=Z)
  main [silicon] = box(corner=(-0.001, -0.001, -0.00075), size=(0.002, 0.002, 0.00075))
  main1 = box(corner=(-0.001, -0.001, -0.00075), size=(0.002, 0.002, 0.00075))
  main1.move(2mm, 0mm, 0mm)
  main2 = box(corner=(-0.001, -0.001, -0.00075), size=(0.002, 0.002, 0.00075))
  main2.move(-2mm, 0mm, 0mm)
  main.unite(main1, main2)
  sample_holder [vacuum] = box(corner=(-0.001, -0.001, -0.00165), size=(0.002, 0.002, 0.00254))
  sample_holder1 = box(corner=(-0.001, -0.001, -0.00165), size=(0.002, 0.002, 0.00254))
  sample_holder1.move(2mm, 0mm, 0mm)
  sample_holder2 = box(corner=(-0.001, -0.001, -0.00165), size=(0.002, 0.002, 0.00254))
  sample_holder2.move(-2mm, 0mm, 0mm)
  sample_holder.unite(sample_holder1, sample_holder2)
  trace_cpw1 = polyline((-0.001, 5e-06, 0) (-0.001, -5e-06, 0))
  trace_cpw1_path = polyline((-0.001, 0, 0) (-7.75e-05, 0, 0))
  trace_cpw1.sweep_along_path(trace_cpw1_path)
  trace_cpw1.move(2mm, 0mm, 0mm)
  trace_cpw2 = polyline((7.75e-05, 5e-06, 0) (7.75e-05, -5e-06, 0))
  trace_cpw2_path = polyline((7.75e-05, 0, 0) (0.001, 0, 0))
  trace_cpw2.sweep_along_path(trace_cpw2_path)
  trace_cpw2.move(2mm, 0mm, 0mm)
  pad_top_CAP1 = rectangle(corner=(-4.75e-05, -2.5e-05, 0), x_size=1e-05, y_size=5e-05)
  pad_top_CAP1.move(2mm, 0mm, 0mm)
  pad_bot_CAP1 = rectangle(corner=(3.75e-05, -2.5e-05, 0), x_size=1e-05, y_size=5e-05)
  pad_bot_CAP1.move(2mm, 0mm, 0mm)
  cent_finger_CAP1 = rectangle(corner=(-3.75e-05, -5e-06, 0), x_size=6.5e-05, y_size=1e-05)
  cent_finger_CAP1.move(2mm, 0mm, 0mm)
  left_finger_CAP1 = rectangle(corner=(-2.75e-05, -2.5e-05, 0), x_size=6.5e-05, y_size=1e-05)
  left_finger_CAP1.move(2mm, 0mm, 0mm)
  right_finger_CAP1 = rectangle(corner=(-2.75e-05, 1.5e-05, 0), x_size=6.5e-05, y_size=1e-05)
  right_finger_CAP1.move(2mm, 0mm, 0mm)
  trace_top_CAP1 = rectangle(corner=(-7.75e-05, -5e-06, 0), x_size=3e-05, y_size=1e-05)
  trace_top_CAP1.move(2mm, 0mm, 0mm)
  trace_bot_CAP1 = rectangle(corner=(4.75e-05, -5e-06, 0), x_size=3e-05, y_size=1e-05)
  trace_bot_CAP1.move(2mm, 0mm, 0mm)
  ground_main_plane1 = rectangle(corner=(-0.001, -0.001, 0), x_size=0.002, y_size=0.002)
  cut_cpw1 = polyline((-0.001, 1.1e-05, 0) (-0.001, -1.1e-05, 0))
  cut_cpw1_path = polyline((-0.001, 0, 0) (-7.75e-05, 0, 0))
  cut_cpw1.sweep_along_path(cut_cpw1_path)
  cut_cpw2 = polyline((7.75e-05, 1.1e-05, 0) (7.75e-05, -1.1e-05, 0))
  cut_cpw2_path = polyline((7.75e-05, 0, 0) (0.001, 0, 0))
  cut_cpw2.sweep_along_path(cut_cpw2_path)
  pocket_CAP1 = rectangle(corner=(-7.75e-05, -3.5e-05, 0), x_size=0.000155, y_size=7e-05)
  ground_main_plane1.subtract(cut_cpw1, cut_cpw2, pocket_CAP1)
  ground_main_plane1.move(2mm, 0mm, 0mm)
  ground_main_plane = rectangle(corner=(-0.001, -0.001, 0), x_size=0.002, y_size=0.002)
  cut_c1 = polyline((-0.001, 1.1e-05, 0) (-0.001, -1.1e-05, 0))
  cut_c1_path = polyline(z=0, xy: (-0.001, 0) (-0.0005, 0) (-0.0005, 0.00055365046) (-0.00025, 0.00055365046) (-0.00025, -0.00055365046) (0, -0.00055365046) (0, 0.00055365046) (0.00025, 0.00055365046) (0.00025, -0.00055365046) (0.0005, -0.00055365046) (0.0005, 0) (0.001, 0))
  cut_c1_path.fillet(Vertices=cut_c1_path.vertex(2 of 12, 3 of 12, 4 of 12, 5 of 12, 6 of 12, 7 of 12, 8 of 12, 9 of 12, 10 of 12, 11 of 12) Radius=0.0001 Setback=0mm)
  cut_c1.sweep_along_path(cut_c1_path)
  ground_main_plane.subtract(cut_c1)
  ground_main_plane2 = rectangle(corner=(-0.001, -0.001, 0), x_size=0.002, y_size=0.002)
  cut_cpw3 = polyline((-0.001, 1.1e-05, 0) (-0.001, -1.1e-05, 0))
  cut_cpw1_path1 = polyline((-0.001, 0, 0) (-7.75e-05, 0, 0))
  cut_cpw3.sweep_along_path(cut_cpw1_path1)
  cut_cpw4 = polyline((7.75e-05, 1.1e-05, 0) (7.75e-05, -1.1e-05, 0))
  cut_cpw2_path1 = polyline((7.75e-05, 0, 0) (0.001, 0, 0))
  cut_cpw4.sweep_along_path(cut_cpw2_path1)
  pocket_CAP2 = rectangle(corner=(-7.75e-05, -3.5e-05, 0), x_size=0.000155, y_size=7e-05)
  ground_main_plane2.subtract(cut_cpw3, cut_cpw4, pocket_CAP2)
  ground_main_plane2.move(-2mm, 0mm, 0mm)
  ground_main_plane1.unite(ground_main_plane, ground_main_plane2)
  trace_cpw3 = polyline((-0.001, 5e-06, 0) (-0.001, -5e-06, 0))
  trace_cpw1_path1 = polyline((-0.001, 0, 0) (-7.75e-05, 0, 0))
  trace_cpw3.sweep_along_path(trace_cpw1_path1)
  trace_cpw3.move(-2mm, 0mm, 0mm)
  trace_cpw4 = polyline((7.75e-05, 5e-06, 0) (7.75e-05, -5e-06, 0))
  trace_cpw2_path1 = polyline((7.75e-05, 0, 0) (0.001, 0, 0))
  trace_cpw4.sweep_along_path(trace_cpw2_path1)
  trace_cpw4.move(-2mm, 0mm, 0mm)
  pad_top_CAP2 = rectangle(corner=(-4.75e-05, -2.5e-05, 0), x_size=1e-05, y_size=5e-05)
  pad_top_CAP2.move(-2mm, 0mm, 0mm)
  pad_bot_CAP2 = rectangle(corner=(3.75e-05, -2.5e-05, 0), x_size=1e-05, y_size=5e-05)
  pad_bot_CAP2.move(-2mm, 0mm, 0mm)
  cent_finger_CAP2 = rectangle(corner=(-3.75e-05, -5e-06, 0), x_size=6.5e-05, y_size=1e-05)
  cent_finger_CAP2.move(-2mm, 0mm, 0mm)
  left_finger_CAP2 = rectangle(corner=(-2.75e-05, -2.5e-05, 0), x_size=6.5e-05, y_size=1e-05)
  left_finger_CAP2.move(-2mm, 0mm, 0mm)
  right_finger_CAP2 = rectangle(corner=(-2.75e-05, 1.5e-05, 0), x_size=6.5e-05, y_size=1e-05)
  right_finger_CAP2.move(-2mm, 0mm, 0mm)
  trace_top_CAP2 = rectangle(corner=(-7.75e-05, -5e-06, 0), x_size=3e-05, y_size=1e-05)
  trace_top_CAP2.move(-2mm, 0mm, 0mm)
  trace_bot_CAP2 = rectangle(corner=(4.75e-05, -5e-06, 0), x_size=3e-05, y_size=1e-05)
  trace_bot_CAP2.move(-2mm, 0mm, 0mm)
boundaries and excitations:
  PerfE: Perfect E Objects=trace_c1
  PerfE1: Perfect E Objects=[trace_cpw1, trace_cpw2, pad_top_CAP1, pad_bot_CAP1, cent_finger_CAP1, left_finger_CAP1, right_finger_CAP1, trace_top_CAP1, trace_bot_CAP1, ground_main_plane1]
  PerfE2: Perfect E Objects=[trace_cpw3, trace_cpw4, pad_top_CAP2, pad_bot_CAP2, cent_finger_CAP2, left_finger_CAP2, right_finger_CAP2, trace_top_CAP2, trace_bot_CAP2]
mesh:
  cpw: LengthBased Objects=trace_c1 MaxLength=0.005mm
  cpw1: LengthBased Objects=[cent_finger_CAP1, left_finger_CAP1, pad_bot_CAP1, pad_top_CAP1, right_finger_CAP1, trace_bot_CAP1, trace_cpw1, trace_cpw2, trace_top_CAP1] MaxLength=0.005mm
  cpw2: LengthBased Objects=[cent_finger_CAP2, left_finger_CAP2, pad_bot_CAP2, pad_top_CAP2, right_finger_CAP2, trace_bot_CAP2, trace_cpw3, trace_cpw4, trace_top_CAP2] MaxLength=0.005mm
setups:
  Setup1: HfssEigen MinimumFrequency=3GHz NumModes=3 MaxDeltaFreq=10 ConvergeOnRealFreq=false MaximumPasses=4 MinimumPasses=1 MinimumConvergedPasses=1 PercentRefinement=30 BasisOrder=1
source amplitudes:
  #-10:1: 1 0deg
  #-10:2, #-10:3: 0 0deg
field plots:
  Mesh1: MeshPlots over cent_finger_CAP1.face(#1098) cent_finger_CAP2.face(#1271) ground_main_plane1.face(all 2) left_finger_CAP1.face(#1111) left_finger_CAP2.face(#1284) pad_bot_CAP1.face(#1085) pad_bot_CAP2.face(#1258) pad_top_CAP1.face(#1072) pad_top_CAP2.face(#1245) right_finger_CAP1.face(#1124) right_finger_CAP2.face(#1297) trace_bot_CAP1.face(#1150) trace_bot_CAP2.face(#1323) trace_c1.face trace_cpw1.face(#1041) trace_cpw2.face(#1054) trace_cpw3.face(#1214) trace_cpw4.face(#1227) trace_top_CAP1.face(#1137) trace_top_CAP2.face(#1310) on Setup1 : LastAdaptive at Phase=0deg

design cap_res_cap (HFSS, DrivenModal, model units mm)
geometry:
  trace_c1 = polyline((-0.001, 5e-06, 0) (-0.001, -5e-06, 0))
  trace_c1_path = polyline(z=0, xy: (-0.001, 0) (-0.0005, 0) (-0.0005, 0.00055365046) (-0.00025, 0.00055365046) (-0.00025, -0.00055365046) (0, -0.00055365046) (0, 0.00055365046) (0.00025, 0.00055365046) (0.00025, -0.00055365046) (0.0005, -0.00055365046) (0.0005, 0) (0.001, 0))
  trace_c1_path.fillet(Vertices=trace_c1_path.vertex(2 of 12, 3 of 12, 4 of 12, 5 of 12, 6 of 12, 7 of 12, 8 of 12, 9 of 12, 10 of 12, 11 of 12) Radius=0.0001 Setback=0mm)
  trace_c1.sweep_along_path(trace_c1_path)
  g_wb [pec] = bondwire(WireType=LOW WireDiameter=0.015mm NumSides=6 XPadPos=-0.00075 YPadPos=-5.5e-05 ZPadPos=0 XDir=0 YDir=1 ZDir=0 Distance=0.00011 h1=0.00011 h2=0mm alpha=80deg beta=80deg WhichAxis=Z)
  g_wb_1 [pec] = bondwire(WireType=LOW WireDiameter=0.015mm NumSides=6 XPadPos=-0.000445 YPadPos=0.00027682523 ZPadPos=0 XDir=-1 YDir=0 ZDir=0 Distance=0.00011 h1=0.00011 h2=0mm alpha=80deg beta=80deg WhichAxis=Z)
  g_wb_2 [pec] = bondwire(WireType=LOW WireDiameter=0.015mm NumSides=6 XPadPos=-0.000305 YPadPos=0.00018455015 ZPadPos=0 XDir=1 YDir=0 ZDir=0 Distance=0.00011 h1=0.00011 h2=0mm alpha=80deg beta=80deg WhichAxis=Z)
  g_wb_3 [pec] = bondwire(WireType=LOW WireDiameter=0.015mm NumSides=6 XPadPos=-0.000305 YPadPos=-0.00018455015 ZPadPos=0 XDir=1 YDir=0 ZDir=0 Distance=0.00011 h1=0.00011 h2=0mm alpha=80deg beta=80deg WhichAxis=Z)
  g_wb_4 [pec] = bondwire(WireType=LOW WireDiameter=0.015mm NumSides=6 XPadPos=5.5e-05 YPadPos=-0.00018455015 ZPadPos=0 XDir=-1 YDir=0 ZDir=0 Distance=0.00011 h1=0.00011 h2=0mm alpha=80deg beta=80deg WhichAxis=Z)
  g_wb_5 [pec] = bondwire(WireType=LOW WireDiameter=0.015mm NumSides=6 XPadPos=5.5e-05 YPadPos=0.00018455015 ZPadPos=0 XDir=-1 YDir=0 ZDir=0 Distance=0.00011 h1=0.00011 h2=0mm alpha=80deg beta=80deg WhichAxis=Z)
  g_wb_6 [pec] = bondwire(WireType=LOW WireDiameter=0.015mm NumSides=6 XPadPos=0.000195 YPadPos=0.00018455015 ZPadPos=0 XDir=1 YDir=0 ZDir=0 Distance=0.00011 h1=0.00011 h2=0mm alpha=80deg beta=80deg WhichAxis=Z)
  g_wb_7 [pec] = bondwire(WireType=LOW WireDiameter=0.015mm NumSides=6 XPadPos=0.000195 YPadPos=-0.00018455015 ZPadPos=0 XDir=1 YDir=0 ZDir=0 Distance=0.00011 h1=0.00011 h2=0mm alpha=80deg beta=80deg WhichAxis=Z)
  g_wb_8 [pec] = bondwire(WireType=LOW WireDiameter=0.015mm NumSides=6 XPadPos=0.000555 YPadPos=-0.00027682523 ZPadPos=0 XDir=-1 YDir=0 ZDir=0 Distance=0.00011 h1=0.00011 h2=0mm alpha=80deg beta=80deg WhichAxis=Z)
  g_wb_9 [pec] = bondwire(WireType=LOW WireDiameter=0.015mm NumSides=6 XPadPos=0.00075 YPadPos=-5.5e-05 ZPadPos=0 XDir=0 YDir=1 ZDir=0 Distance=0.00011 h1=0.00011 h2=0mm alpha=80deg beta=80deg WhichAxis=Z)
  ground_main_plane = rectangle(corner=(-0.001, -0.001, 0), x_size=0.002, y_size=0.002)
  cut_c1 = polyline((-0.001, 1.1e-05, 0) (-0.001, -1.1e-05, 0))
  cut_c1_path = polyline(z=0, xy: (-0.001, 0) (-0.0005, 0) (-0.0005, 0.00055365046) (-0.00025, 0.00055365046) (-0.00025, -0.00055365046) (0, -0.00055365046) (0, 0.00055365046) (0.00025, 0.00055365046) (0.00025, -0.00055365046) (0.0005, -0.00055365046) (0.0005, 0) (0.001, 0))
  cut_c1_path.fillet(Vertices=cut_c1_path.vertex(2 of 12, 3 of 12, 4 of 12, 5 of 12, 6 of 12, 7 of 12, 8 of 12, 9 of 12, 10 of 12, 11 of 12) Radius=0.0001 Setback=0mm)
  cut_c1.sweep_along_path(cut_c1_path)
  ground_main_plane.subtract(cut_c1)
  main [silicon] = box(corner=(-0.001, -0.001, -0.00075), size=(0.002, 0.002, 0.00075))
  sample_holder [vacuum] = box(corner=(-0.001, -0.001, -0.00165), size=(0.002, 0.002, 0.00254))
  trace_cpw1 = polyline((-0.001, 5e-06, 0) (-0.001, -5e-06, 0))
  trace_cpw1_path = polyline((-0.001, 0, 0) (-7.75e-05, 0, 0))
  trace_cpw1.sweep_along_path(trace_cpw1_path)
  trace_cpw2 = polyline((7.75e-05, 5e-06, 0) (7.75e-05, -5e-06, 0))
  trace_cpw2_path = polyline((7.75e-05, 0, 0) (0.001, 0, 0))
  trace_cpw2.sweep_along_path(trace_cpw2_path)
  pad_top_CAP1 = rectangle(corner=(-4.75e-05, -2.5e-05, 0), x_size=1e-05, y_size=5e-05)
  pad_bot_CAP1 = rectangle(corner=(3.75e-05, -2.5e-05, 0), x_size=1e-05, y_size=5e-05)
  cent_finger_CAP1 = rectangle(corner=(-3.75e-05, -5e-06, 0), x_size=6.5e-05, y_size=1e-05)
  left_finger_CAP1 = rectangle(corner=(-2.75e-05, -2.5e-05, 0), x_size=6.5e-05, y_size=1e-05)
  right_finger_CAP1 = rectangle(corner=(-2.75e-05, 1.5e-05, 0), x_size=6.5e-05, y_size=1e-05)
  trace_top_CAP1 = rectangle(corner=(-7.75e-05, -5e-06, 0), x_size=3e-05, y_size=1e-05)
  trace_bot_CAP1 = rectangle(corner=(4.75e-05, -5e-06, 0), x_size=3e-05, y_size=1e-05)
  ground_main_plane1 = rectangle(corner=(-0.001, -0.001, 0), x_size=0.002, y_size=0.002)
  cut_cpw1 = polyline((-0.001, 1.1e-05, 0) (-0.001, -1.1e-05, 0))
  cut_cpw1_path = polyline((-0.001, 0, 0) (-7.75e-05, 0, 0))
  cut_cpw1.sweep_along_path(cut_cpw1_path)
  cut_cpw2 = polyline((7.75e-05, 1.1e-05, 0) (7.75e-05, -1.1e-05, 0))
  cut_cpw2_path = polyline((7.75e-05, 0, 0) (0.001, 0, 0))
  cut_cpw2.sweep_along_path(cut_cpw2_path)
  pocket_CAP1 = rectangle(corner=(-7.75e-05, -3.5e-05, 0), x_size=0.000155, y_size=7e-05)
  ground_main_plane1.subtract(cut_cpw1, cut_cpw2, pocket_CAP1)
  main1 = box(corner=(-0.001, -0.001, -0.00075), size=(0.002, 0.002, 0.00075))
  sample_holder1 = box(corner=(-0.001, -0.001, -0.00165), size=(0.002, 0.002, 0.00254))
  WP2 = rectangle(corner=(0.001, -0.0005, -0.0005), y_size=0.001, z_size=0.001)
  [trace_cpw1, trace_cpw2, pad_top_CAP1, pad_bot_CAP1, cent_finger_CAP1, left_finger_CAP1, right_finger_CAP1, trace_top_CAP1, trace_bot_CAP1, ground_main_plane1, main1, sample_holder1, WP2].move(2mm, 0mm, 0mm)
  trace_cpw3 = polyline((-0.001, 5e-06, 0) (-0.001, -5e-06, 0))
  trace_cpw1_path1 = polyline((-0.001, 0, 0) (-7.75e-05, 0, 0))
  trace_cpw3.sweep_along_path(trace_cpw1_path1)
  trace_cpw4 = polyline((7.75e-05, 5e-06, 0) (7.75e-05, -5e-06, 0))
  trace_cpw2_path1 = polyline((7.75e-05, 0, 0) (0.001, 0, 0))
  trace_cpw4.sweep_along_path(trace_cpw2_path1)
  pad_top_CAP2 = rectangle(corner=(-4.75e-05, -2.5e-05, 0), x_size=1e-05, y_size=5e-05)
  pad_bot_CAP2 = rectangle(corner=(3.75e-05, -2.5e-05, 0), x_size=1e-05, y_size=5e-05)
  cent_finger_CAP2 = rectangle(corner=(-3.75e-05, -5e-06, 0), x_size=6.5e-05, y_size=1e-05)
  left_finger_CAP2 = rectangle(corner=(-2.75e-05, -2.5e-05, 0), x_size=6.5e-05, y_size=1e-05)
  right_finger_CAP2 = rectangle(corner=(-2.75e-05, 1.5e-05, 0), x_size=6.5e-05, y_size=1e-05)
  trace_top_CAP2 = rectangle(corner=(-7.75e-05, -5e-06, 0), x_size=3e-05, y_size=1e-05)
  trace_bot_CAP2 = rectangle(corner=(4.75e-05, -5e-06, 0), x_size=3e-05, y_size=1e-05)
  ground_main_plane2 = rectangle(corner=(-0.001, -0.001, 0), x_size=0.002, y_size=0.002)
  cut_cpw3 = polyline((-0.001, 1.1e-05, 0) (-0.001, -1.1e-05, 0))
  cut_cpw1_path1 = polyline((-0.001, 0, 0) (-7.75e-05, 0, 0))
  cut_cpw3.sweep_along_path(cut_cpw1_path1)
  cut_cpw4 = polyline((7.75e-05, 1.1e-05, 0) (7.75e-05, -1.1e-05, 0))
  cut_cpw2_path1 = polyline((7.75e-05, 0, 0) (0.001, 0, 0))
  cut_cpw4.sweep_along_path(cut_cpw2_path1)
  pocket_CAP2 = rectangle(corner=(-7.75e-05, -3.5e-05, 0), x_size=0.000155, y_size=7e-05)
  ground_main_plane2.subtract(cut_cpw3, cut_cpw4, pocket_CAP2)
  main2 = box(corner=(-0.001, -0.001, -0.00075), size=(0.002, 0.002, 0.00075))
  sample_holder2 = box(corner=(-0.001, -0.001, -0.00165), size=(0.002, 0.002, 0.00254))
  WP1 = rectangle(corner=(-0.001, -0.0005, -0.0005), y_size=0.001, z_size=0.001)
  [trace_cpw3, trace_cpw4, pad_top_CAP2, pad_bot_CAP2, cent_finger_CAP2, left_finger_CAP2, right_finger_CAP2, trace_top_CAP2, trace_bot_CAP2, ground_main_plane2, main2, sample_holder2, WP1].move(-2mm, 0mm, 0mm)
  sample_holder.unite(sample_holder1, sample_holder2)
  main.unite(main1, main2)
  ground_main_plane1.unite(ground_main_plane, ground_main_plane2)
boundaries and excitations:
  PerfE: Perfect E Objects=trace_c1
  PerfE1: Perfect E Objects=[trace_cpw1, trace_cpw2, pad_top_CAP1, pad_bot_CAP1, cent_finger_CAP1, left_finger_CAP1, right_finger_CAP1, trace_top_CAP1, trace_bot_CAP1, ground_main_plane1]
  PerfE2: Perfect E Objects=[trace_cpw3, trace_cpw4, pad_top_CAP2, pad_bot_CAP2, cent_finger_CAP2, left_finger_CAP2, right_finger_CAP2, trace_top_CAP2, trace_bot_CAP2]
  WP2: Wave Port Objects=WP2 NumModes=1 Modes{Mode1{IntLine{middle of main.edge(1 of 12) -> ground_main_plane1.vertex(#1512)} CharImp=Zpi RenormImp=50ohm}}
  WP1: Wave Port Objects=WP1 NumModes=1 Modes{Mode1{IntLine{middle of main.edge(3 of 12) -> ground_main_plane1.vertex(#1807)} CharImp=Zpi RenormImp=50ohm}}
mesh:
  cpw: LengthBased Objects=trace_c1 MaxLength=0.005mm
  cpw1: LengthBased Objects=[cent_finger_CAP1, left_finger_CAP1, pad_bot_CAP1, pad_top_CAP1, right_finger_CAP1, trace_bot_CAP1, trace_cpw1, trace_cpw2, trace_top_CAP1] MaxLength=0.005mm
  cpw2: LengthBased Objects=[cent_finger_CAP2, left_finger_CAP2, pad_bot_CAP2, pad_top_CAP2, right_finger_CAP2, trace_bot_CAP2, trace_cpw3, trace_cpw4, trace_top_CAP2] MaxLength=0.005mm
setups:
  SingleFreq_20_5GHz: HfssDriven Frequency=20.5GHz MaxDeltaS=0.01 MaximumPasses=15 MinimumPasses=1 MinimumConvergedPasses=1 PercentRefinement=30 BasisOrder=1 PortAccuracy=2
    sweep Int: 500MHz to 20.5GHz, 25000 points; Type=Interpolating InterpTolerance=0.5 InterpMaxSolns=250 InterpUsePortImped=false PassivityErrorTolerance=0.0001
source amplitudes:
  WP2:1: 1W 0deg
  WP1:1: 0W 0deg
field plots:
  Mesh1: MeshPlots over cent_finger_CAP1.face(#1425) cent_finger_CAP2.face(#1724) ground_main_plane1.face(all 2) left_finger_CAP1.face(#1437) left_finger_CAP2.face(#1736) pad_bot_CAP1.face(#1413) pad_bot_CAP2.face(#1712) pad_top_CAP1.face(#1401) pad_top_CAP2.face(#1700) right_finger_CAP1.face(#1449) right_finger_CAP2.face(#1748) trace_bot_CAP1.face(#1473) trace_bot_CAP2.face(#1772) trace_c1.face trace_cpw1.face(#1372) trace_cpw2.face(#1384) trace_cpw3.face(#1671) trace_cpw4.face(#1683) trace_top_CAP1.face(#1461) trace_top_CAP2.face(#1760) WP1.face(#1881) WP2.face(#1594) on SingleFreq_20_5GHz : LastAdaptive at Freq=20.5GHz Phase=0deg
  Mesh2: MeshPlots over cent_finger_CAP1.face(#1425) cent_finger_CAP2.face(#1724) ground_main_plane1.face(all 2) left_finger_CAP1.face(#1437) left_finger_CAP2.face(#1736) pad_bot_CAP1.face(#1413) pad_bot_CAP2.face(#1712) pad_top_CAP1.face(#1401) pad_top_CAP2.face(#1700) right_finger_CAP1.face(#1449) right_finger_CAP2.face(#1748) trace_bot_CAP1.face(#1473) trace_bot_CAP2.face(#1772) trace_c1.face trace_cpw1.face(#1372) trace_cpw2.face(#1384) trace_cpw3.face(#1671) trace_cpw4.face(#1683) trace_top_CAP1.face(#1461) trace_top_CAP2.face(#1760) g_wb.face(all 20) g_wb_1.face(all 20) g_wb_2.face(all 20) g_wb_3.face(all 20) g_wb_4.face(all 20) g_wb_5.face(all 20) g_wb_6.face(all 20) g_wb_7.face(all 20) g_wb_8.face(all 20) g_wb_9.face(all 20) on SingleFreq_20_5GHz : LastAdaptive at Freq=20.5GHz Phase=0deg
reports:
  S Parameter Plot 1: dB(S(WP1,WP1)), dB(S(WP2,WP1)), dB(S(WP1,WP2)), dB(S(WP2,WP2)) vs Freq on SingleFreq_20_5GHz : Int; markers MX1 at x=7.2722686e+09, MX2 at x=1.4540441e+10
  Z Parameter Plot 1: dB20(Z(WP1,WP1)), dB20(Z(WP2,WP1)), dB20(Z(WP1,WP2)), dB20(Z(WP2,WP2)) vs Freq on SingleFreq_20_5GHz : Int

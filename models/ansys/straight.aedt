# Ansys Electronics Desktop project, version 2021.2
materials:
  vacuum: permittivity=1
  silicon: permittivity=11.9

design straight (HFSS, DrivenModal, model units mm)
geometry:
  trace_cpw_path = polyline((-0.001, 0, 0) (0.001, 0, 0))
  trace_cpw = polyline((-0.001, 5e-06, 0) (-0.001, -5e-06, 0))
  trace_cpw.sweep_along_path(trace_cpw_path)
  cut_cpw_path = polyline((-0.001, 0, 0) (0.001, 0, 0))
  cut_cpw = polyline((-0.001, 1.1e-05, 0) (-0.001, -1.1e-05, 0))
  cut_cpw.sweep_along_path(cut_cpw_path)
  ground_main_plane = rectangle(corner=(-0.001, -0.001, 0), x_size=0.002, y_size=0.002)
  main [silicon] = box(corner=(-0.001, -0.001, -0.00075), size=(0.002, 0.002, 0.00075))
  sample_holder [vacuum] = box(corner=(-0.001, -0.001, -0.00165), size=(0.002, 0.002, 0.00254))
  ground_main_plane.subtract(cut_cpw)
  WP1 = rectangle(corner=(-0.001, -0.0005, -0.00025), y_size=0.001, z_size=0.0005)
  WP2 = rectangle(corner=(0.001, -0.0005, -0.00025), y_size=0.001, z_size=0.0005)
boundaries and excitations:
  PerfE: Perfect E Objects=[trace_cpw, ground_main_plane]
  WP1: Wave Port Objects=WP1 NumModes=1 Modes{Mode1{IntLine{middle of main.edge(3 of 12) -> ground_main_plane.vertex(#118)} CharImp=Zpi RenormImp=50ohm}}
  WP2: Wave Port Objects=WP2 NumModes=1 Modes{Mode1{IntLine{middle of main.edge(1 of 12) -> ground_main_plane.vertex(#116)} CharImp=Zpi RenormImp=50ohm}}
mesh:
  cpw: LengthBased Objects=trace_cpw MaxLength=0.005mm
setups:
  SingleFreq_20_5GHz: HfssDriven Frequency=20.5GHz MaxDeltaS=0.01 MaximumPasses=15 MinimumPasses=1 MinimumConvergedPasses=1 PercentRefinement=30 BasisOrder=1 PortAccuracy=2
    sweep Int: 500MHz to 20.5GHz, 25000 points; Type=Interpolating InterpTolerance=0.5 InterpMaxSolns=250 InterpUsePortImped=false PassivityErrorTolerance=0.0001
source amplitudes:
  WP1:1: 1W 0deg
  WP2:1: 0W 0deg
field plots:
  Mesh1: MeshPlots over ground_main_plane.face(all 2) trace_cpw.face WP1.face WP2.face on SingleFreq_20_5GHz : LastAdaptive at Freq=20.5GHz Phase=0deg
  Mesh2: MeshPlots over WP1.face WP2.face on SingleFreq_20_5GHz : LastAdaptive at Freq=20.5GHz Phase=0deg
reports:
  S Parameter Plot 1: dB(S(WP1,WP1)), dB(S(WP2,WP1)), dB(S(WP1,WP2)), dB(S(WP2,WP2)) vs Freq on SingleFreq_20_5GHz : Int
  Z Parameter Plot 1: dB20(Z(WP1,WP1)), dB20(Z(WP2,WP1)), dB20(Z(WP1,WP2)), dB20(Z(WP2,WP2)) vs Freq on SingleFreq_20_5GHz : Int
